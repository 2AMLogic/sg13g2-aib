* Generated by layout/lvs/gen_reference.py -- DO NOT EDIT BY HAND.
* Plain-element form for `klt lvs`; flattened from the item 1 netlists:
*   design/aib_pad_esd.spice sha256:3cb704eb07544c97702c141626fe54285850dfc17a7ca20932c3bc24c6609489
*   design/aib_tx_data.spice sha256:667c53139825da4804873cab2f2038c4576063c466dfb9ce16c1a9a527bbf545
*   design/aib_rx_data.spice sha256:7863828c03ab4412c465be9931b6f8172fc90fe572ec64c72c4bb36cc34d6774
*   design/aib_rx_inv.spice sha256:8cd42264f8014ff28951be5fb52e9ed94fadb94b89fc99aba5291e6d6b8b90fe
*   design/aib_tx_clk.spice sha256:35de4d0bc6f1ad109c1477efa0cde485ae7a39f1b90005e92a2a0fd7db55e248
*   design/aib_rx_clk.spice sha256:3675d8bb85f776fda07a1183adfd3b846062bd034c49d054a4f905cf58a95bb7
.SUBCKT aib_io_column DIN DIN$1 DIN$2 DIN$3 DIN$4 DIN$5 DIN$6 DIN$7 DIN$8 DIN$9 DIN$10 DIN$11 DIN$12 DIN$13 DIN$14 DIN$15 DIN$16 DIN$17 DIN$18 DIN$19 DIN$20 DIN$21 DIN$22 DIN$23 DOUT DOUT$1 DOUT$2 DOUT$3 DOUT$4 DOUT$5 DOUT$6 DOUT$7 DOUT$8 DOUT$9 DOUT$10 DOUT$11 DOUT$12 DOUT$13 DOUT$14 DOUT$15 DOUT$16 DOUT$17 DOUT$18 DOUT$19 DOUT$20 DOUT$21 DOUT$22 DOUT$23 OE PAD PAD$1 PAD$2 PAD$3 PAD$4 PAD$5 PAD$6 PAD$7 PAD$8 PAD$9 PAD$10 PAD$11 PAD$12 PAD$13 PAD$14 PAD$15 PAD$16 PAD$17 PAD$18 PAD$19 PAD$20 PAD$21 PAD$22 PAD$23 PAD$24 PAD$25 PAD$26 PAD$27 PAD$28 PAD$29 PAD$30 PAD$31 PAD$32 PAD$33 PAD$34 PAD$35 PAD$36 PAD$37 PAD$38 PAD$39 PAD$40 PAD$41 PAD$42 PAD$43 PAD$44 PAD$45 PAD$46 PAD$47 PD PUN VDDIO VSS
Dt0esd_Dp1 PAD$1 VDDIO diodevdd_mod A=35P P=58.08U
Dt0esd_Dp1_dsub VSS VDDIO dsub_2kv_mod A=224.956P P=81.12U
Mt0esd_Mn1_f0 PAD$1 VSS VSS VSS nfet L=0.13U W=2U
Mt0esd_Mn1_f1 PAD$1 VSS VSS VSS nfet L=0.13U W=2U
Mt0esd_Mn1_f2 PAD$1 VSS VSS VSS nfet L=0.13U W=2U
Mt0esd_Mn1_f3 PAD$1 VSS VSS VSS nfet L=0.13U W=2U
Mt0esd_Mn1_f4 PAD$1 VSS VSS VSS nfet L=0.13U W=2U
Mt0esd_Mn1_f5 PAD$1 VSS VSS VSS nfet L=0.13U W=2U
Mt0esd_Mn1_f6 PAD$1 VSS VSS VSS nfet L=0.13U W=2U
Mt0esd_Mn1_f7 PAD$1 VSS VSS VSS nfet L=0.13U W=2U
Mt0esd_Mn1_f8 PAD$1 VSS VSS VSS nfet L=0.13U W=2U
Mt0esd_Mn1_f9 PAD$1 VSS VSS VSS nfet L=0.13U W=2U
Mt0esd_Mclamp_f0 VDDIO VDDIO VSS VSS nfet L=0.35U W=2U
Mt0esd_Mclamp_f1 VDDIO VSS VSS VSS nfet L=0.35U W=2U
Mt0esd_Mclamp_f2 VDDIO VSS VSS VSS nfet L=0.35U W=2U
Mt0esd_Mclamp_f3 VDDIO VSS VSS VSS nfet L=0.35U W=2U
Mt0esd_Mclamp_f4 VDDIO VSS VSS VSS nfet L=0.35U W=2U
Mt0esd_Mclamp_f5 VDDIO VSS VSS VSS nfet L=0.35U W=2U
Mt0esd_Mclamp_f6 VDDIO VSS VSS VSS nfet L=0.35U W=2U
Mt0esd_Mclamp_f7 VDDIO VSS VSS VSS nfet L=0.35U W=2U
Mt0esd_Mclamp_f8 VDDIO VSS VSS VSS nfet L=0.35U W=2U
Mt0esd_Mclamp_f9 VDDIO VSS VSS VSS nfet L=0.35U W=2U
Mt0esd_Mclamp_f10 VDDIO VSS VSS VSS nfet L=0.35U W=2U
Mt0esd_Mclamp_f11 VDDIO VSS VSS VSS nfet L=0.35U W=2U
Mt0esd_Mclamp_f12 VDDIO VSS VSS VSS nfet L=0.35U W=2U
Mt0esd_Mclamp_f13 VDDIO VSS VSS VSS nfet L=0.35U W=2U
Mt0esd_Mclamp_f14 VDDIO VSS VSS VSS nfet L=0.35U W=2U
Mt0esd_Mclamp_f15 VDDIO VSS VSS VSS nfet L=0.35U W=2U
Mt0esd_Mclamp_f16 VDDIO VSS VSS VSS nfet L=0.35U W=2U
Mt0esd_Mclamp_f17 VDDIO VSS VSS VSS nfet L=0.35U W=2U
Mt0esd_Mclamp_f18 VDDIO VSS VSS VSS nfet L=0.35U W=2U
Mt0esd_Mclamp_f19 VDDIO VSS VSS VSS nfet L=0.35U W=2U
Xt0esd_Resd PAD$1 PADI_T0 VSS rppd r=164.6 L=1U W=2U
Dt0esd_Dp2 PADI_T0 VDDIO dpantenna A=4P P=8U
Mt0esd_Mn2_f0 PADI_T0 VSS VSS VSS nfet L=0.13U W=1U
Mt0tx_Mi1p_f0 t0tx/OEB OE VDDIO VDDIO pfet L=0.13U W=2U
Mt0tx_Mi1n_f0 t0tx/OEB OE VSS VSS nfet L=0.13U W=1U
Mt0tx_Mnd1p_f0 t0tx/GP DIN VDDIO VDDIO pfet L=0.13U W=2U
Mt0tx_Mnd1p_f1 t0tx/GP DIN VDDIO VDDIO pfet L=0.13U W=2U
Mt0tx_Mnd2p_f0 t0tx/GP OE VDDIO VDDIO pfet L=0.13U W=2U
Mt0tx_Mnd2p_f1 t0tx/GP OE VDDIO VDDIO pfet L=0.13U W=2U
Mt0tx_Mnd1n_f0 t0tx/GP DIN t0tx/NA VSS nfet L=0.13U W=2U
Mt0tx_Mnd1n_f1 t0tx/GP DIN t0tx/NA VSS nfet L=0.13U W=2U
Mt0tx_Mnd2n_f0 t0tx/NA OE VSS VSS nfet L=0.13U W=2U
Mt0tx_Mnd2n_f1 t0tx/NA OE VSS VSS nfet L=0.13U W=2U
Mt0tx_Mnr1p_f0 t0tx/NB DIN VDDIO VDDIO pfet L=0.13U W=2U
Mt0tx_Mnr1p_f1 t0tx/NB DIN VDDIO VDDIO pfet L=0.13U W=2U
Mt0tx_Mnr1p_f2 t0tx/NB DIN VDDIO VDDIO pfet L=0.13U W=2U
Mt0tx_Mnr1p_f3 t0tx/NB DIN VDDIO VDDIO pfet L=0.13U W=2U
Mt0tx_Mnr2p_f0 t0tx/GN t0tx/OEB t0tx/NB VDDIO pfet L=0.13U W=2U
Mt0tx_Mnr2p_f1 t0tx/GN t0tx/OEB t0tx/NB VDDIO pfet L=0.13U W=2U
Mt0tx_Mnr2p_f2 t0tx/GN t0tx/OEB t0tx/NB VDDIO pfet L=0.13U W=2U
Mt0tx_Mnr2p_f3 t0tx/GN t0tx/OEB t0tx/NB VDDIO pfet L=0.13U W=2U
Mt0tx_Mnr1n_f0 t0tx/GN DIN VSS VSS nfet L=0.13U W=1U
Mt0tx_Mnr1n_f1 t0tx/GN DIN VSS VSS nfet L=0.13U W=1U
Mt0tx_Mnr2n_f0 t0tx/GN t0tx/OEB VSS VSS nfet L=0.13U W=1U
Mt0tx_Mnr2n_f1 t0tx/GN t0tx/OEB VSS VSS nfet L=0.13U W=1U
Mt0tx_Mp_f0 t0tx/DP t0tx/GP VDDIO VDDIO pfet L=0.13U W=1U
Mt0tx_Mp_f1 t0tx/DP t0tx/GP VDDIO VDDIO pfet L=0.13U W=1U
Mt0tx_Mp_f2 t0tx/DP t0tx/GP VDDIO VDDIO pfet L=0.13U W=1U
Mt0tx_Mp_f3 t0tx/DP t0tx/GP VDDIO VDDIO pfet L=0.13U W=1U
Mt0tx_Mp_f4 t0tx/DP t0tx/GP VDDIO VDDIO pfet L=0.13U W=1U
Mt0tx_Mp_f5 t0tx/DP t0tx/GP VDDIO VDDIO pfet L=0.13U W=1U
Mt0tx_Mp_f6 t0tx/DP t0tx/GP VDDIO VDDIO pfet L=0.13U W=1U
Mt0tx_Mp_f7 t0tx/DP t0tx/GP VDDIO VDDIO pfet L=0.13U W=1U
Mt0tx_Mp_f8 t0tx/DP t0tx/GP VDDIO VDDIO pfet L=0.13U W=1U
Mt0tx_Mp_f9 t0tx/DP t0tx/GP VDDIO VDDIO pfet L=0.13U W=1U
Mt0tx_Mp_f10 t0tx/DP t0tx/GP VDDIO VDDIO pfet L=0.13U W=1U
Mt0tx_Mp_f11 t0tx/DP t0tx/GP VDDIO VDDIO pfet L=0.13U W=1U
Mt0tx_Mp_f12 t0tx/DP t0tx/GP VDDIO VDDIO pfet L=0.13U W=1U
Mt0tx_Mp_f13 t0tx/DP t0tx/GP VDDIO VDDIO pfet L=0.13U W=1U
Mt0tx_Mp_f14 t0tx/DP t0tx/GP VDDIO VDDIO pfet L=0.13U W=1U
Mt0tx_Mp_f15 t0tx/DP t0tx/GP VDDIO VDDIO pfet L=0.13U W=1U
Mt0tx_Mp_f16 t0tx/DP t0tx/GP VDDIO VDDIO pfet L=0.13U W=1U
Mt0tx_Mp_f17 t0tx/DP t0tx/GP VDDIO VDDIO pfet L=0.13U W=1U
Mt0tx_Mp_f18 t0tx/DP t0tx/GP VDDIO VDDIO pfet L=0.13U W=1U
Mt0tx_Mp_f19 t0tx/DP t0tx/GP VDDIO VDDIO pfet L=0.13U W=1U
Mt0tx_Mp_f20 t0tx/DP t0tx/GP VDDIO VDDIO pfet L=0.13U W=1U
Mt0tx_Mp_f21 t0tx/DP t0tx/GP VDDIO VDDIO pfet L=0.13U W=1U
Mt0tx_Mp_f22 t0tx/DP t0tx/GP VDDIO VDDIO pfet L=0.13U W=1U
Mt0tx_Mp_f23 t0tx/DP t0tx/GP VDDIO VDDIO pfet L=0.13U W=1U
Mt0tx_Mp_f24 t0tx/DP t0tx/GP VDDIO VDDIO pfet L=0.13U W=1U
Mt0tx_Mp_f25 t0tx/DP t0tx/GP VDDIO VDDIO pfet L=0.13U W=1U
Mt0tx_Mp_f26 t0tx/DP t0tx/GP VDDIO VDDIO pfet L=0.13U W=1U
Mt0tx_Mp_f27 t0tx/DP t0tx/GP VDDIO VDDIO pfet L=0.13U W=1U
Mt0tx_Mp_f28 t0tx/DP t0tx/GP VDDIO VDDIO pfet L=0.13U W=1U
Mt0tx_Mp_f29 t0tx/DP t0tx/GP VDDIO VDDIO pfet L=0.13U W=1U
Mt0tx_Mp_f30 t0tx/DP t0tx/GP VDDIO VDDIO pfet L=0.13U W=1U
Mt0tx_Mp_f31 t0tx/DP t0tx/GP VDDIO VDDIO pfet L=0.13U W=1U
Mt0tx_Mp_f32 t0tx/DP t0tx/GP VDDIO VDDIO pfet L=0.13U W=1U
Mt0tx_Mp_f33 t0tx/DP t0tx/GP VDDIO VDDIO pfet L=0.13U W=1U
Mt0tx_Mp_f34 t0tx/DP t0tx/GP VDDIO VDDIO pfet L=0.13U W=1U
Mt0tx_Mp_f35 t0tx/DP t0tx/GP VDDIO VDDIO pfet L=0.13U W=1U
Mt0tx_Mp_f36 t0tx/DP t0tx/GP VDDIO VDDIO pfet L=0.13U W=1U
Mt0tx_Mp_f37 t0tx/DP t0tx/GP VDDIO VDDIO pfet L=0.13U W=1U
Mt0tx_Mp_f38 t0tx/DP t0tx/GP VDDIO VDDIO pfet L=0.13U W=1U
Mt0tx_Mp_f39 t0tx/DP t0tx/GP VDDIO VDDIO pfet L=0.13U W=1U
Mt0tx_Mp_f40 t0tx/DP t0tx/GP VDDIO VDDIO pfet L=0.13U W=1U
Mt0tx_Mp_f41 t0tx/DP t0tx/GP VDDIO VDDIO pfet L=0.13U W=1U
Mt0tx_Mp_f42 t0tx/DP t0tx/GP VDDIO VDDIO pfet L=0.13U W=1U
Mt0tx_Mp_f43 t0tx/DP t0tx/GP VDDIO VDDIO pfet L=0.13U W=1U
Mt0tx_Mp_f44 t0tx/DP t0tx/GP VDDIO VDDIO pfet L=0.13U W=1U
Mt0tx_Mp_f45 t0tx/DP t0tx/GP VDDIO VDDIO pfet L=0.13U W=1U
Mt0tx_Mp_f46 t0tx/DP t0tx/GP VDDIO VDDIO pfet L=0.13U W=1U
Mt0tx_Mp_f47 t0tx/DP t0tx/GP VDDIO VDDIO pfet L=0.13U W=1U
Mt0tx_Mp_f48 t0tx/DP t0tx/GP VDDIO VDDIO pfet L=0.13U W=1U
Mt0tx_Mp_f49 t0tx/DP t0tx/GP VDDIO VDDIO pfet L=0.13U W=1U
Mt0tx_Mp_f50 t0tx/DP t0tx/GP VDDIO VDDIO pfet L=0.13U W=1U
Mt0tx_Mp_f51 t0tx/DP t0tx/GP VDDIO VDDIO pfet L=0.13U W=1U
Mt0tx_Mp_f52 t0tx/DP t0tx/GP VDDIO VDDIO pfet L=0.13U W=1U
Mt0tx_Mp_f53 t0tx/DP t0tx/GP VDDIO VDDIO pfet L=0.13U W=1U
Mt0tx_Mn_f0 t0tx/DN t0tx/GN VSS VSS nfet L=0.13U W=1U
Mt0tx_Mn_f1 t0tx/DN t0tx/GN VSS VSS nfet L=0.13U W=1U
Mt0tx_Mn_f2 t0tx/DN t0tx/GN VSS VSS nfet L=0.13U W=1U
Mt0tx_Mn_f3 t0tx/DN t0tx/GN VSS VSS nfet L=0.13U W=1U
Mt0tx_Mn_f4 t0tx/DN t0tx/GN VSS VSS nfet L=0.13U W=1U
Mt0tx_Mn_f5 t0tx/DN t0tx/GN VSS VSS nfet L=0.13U W=1U
Mt0tx_Mn_f6 t0tx/DN t0tx/GN VSS VSS nfet L=0.13U W=1U
Mt0tx_Mn_f7 t0tx/DN t0tx/GN VSS VSS nfet L=0.13U W=1U
Mt0tx_Mn_f8 t0tx/DN t0tx/GN VSS VSS nfet L=0.13U W=1U
Mt0tx_Mn_f9 t0tx/DN t0tx/GN VSS VSS nfet L=0.13U W=1U
Mt0tx_Mn_f10 t0tx/DN t0tx/GN VSS VSS nfet L=0.13U W=1U
Mt0tx_Mn_f11 t0tx/DN t0tx/GN VSS VSS nfet L=0.13U W=1U
Mt0tx_Mn_f12 t0tx/DN t0tx/GN VSS VSS nfet L=0.13U W=1U
Mt0tx_Mn_f13 t0tx/DN t0tx/GN VSS VSS nfet L=0.13U W=1U
Mt0tx_Mn_f14 t0tx/DN t0tx/GN VSS VSS nfet L=0.13U W=1U
Mt0tx_Mn_f15 t0tx/DN t0tx/GN VSS VSS nfet L=0.13U W=1U
Mt0tx_Mn_f16 t0tx/DN t0tx/GN VSS VSS nfet L=0.13U W=1U
Mt0tx_Mn_f17 t0tx/DN t0tx/GN VSS VSS nfet L=0.13U W=1U
Mt0tx_Mn_f18 t0tx/DN t0tx/GN VSS VSS nfet L=0.13U W=1U
Mt0tx_Mn_f19 t0tx/DN t0tx/GN VSS VSS nfet L=0.13U W=1U
Mt0tx_Mn_f20 t0tx/DN t0tx/GN VSS VSS nfet L=0.13U W=1U
Mt0tx_Mn_f21 t0tx/DN t0tx/GN VSS VSS nfet L=0.13U W=1U
Mt0tx_Mpu_f0 t0tx/PUX PUN VDDIO VDDIO pfet L=0.13U W=2U
Xt0tx_Rpu t0tx/PUX PAD$1 VSS rppd r=12472.0 L=24U W=0.5U
Mt0tx_Mpd_f0 t0tx/PDX PD VSS VSS nfet L=0.13U W=1U
Xt0tx_Rpd PAD$1 t0tx/PDX VSS rppd r=12472.0 L=24U W=0.5U
Xt0tx_Rsp t0tx/DP PAD$1 VSS rppd r=20.0 L=0.5U W=10U
Xt0tx_Rsn t0tx/DN PAD$1 VSS rppd r=20.0 L=0.5U W=10U
Dt1esd_Dp1 PAD$3 VDDIO diodevdd_mod A=35P P=58.08U
Dt1esd_Dp1_dsub VSS VDDIO dsub_2kv_mod A=224.956P P=81.12U
Mt1esd_Mn1_f0 PAD$3 VSS VSS VSS nfet L=0.13U W=2U
Mt1esd_Mn1_f1 PAD$3 VSS VSS VSS nfet L=0.13U W=2U
Mt1esd_Mn1_f2 PAD$3 VSS VSS VSS nfet L=0.13U W=2U
Mt1esd_Mn1_f3 PAD$3 VSS VSS VSS nfet L=0.13U W=2U
Mt1esd_Mn1_f4 PAD$3 VSS VSS VSS nfet L=0.13U W=2U
Mt1esd_Mn1_f5 PAD$3 VSS VSS VSS nfet L=0.13U W=2U
Mt1esd_Mn1_f6 PAD$3 VSS VSS VSS nfet L=0.13U W=2U
Mt1esd_Mn1_f7 PAD$3 VSS VSS VSS nfet L=0.13U W=2U
Mt1esd_Mn1_f8 PAD$3 VSS VSS VSS nfet L=0.13U W=2U
Mt1esd_Mn1_f9 PAD$3 VSS VSS VSS nfet L=0.13U W=2U
Mt1esd_Mclamp_f0 VDDIO VSS VSS VSS nfet L=0.35U W=2U
Mt1esd_Mclamp_f1 VDDIO VSS VSS VSS nfet L=0.35U W=2U
Mt1esd_Mclamp_f2 VDDIO VSS VSS VSS nfet L=0.35U W=2U
Mt1esd_Mclamp_f3 VDDIO VSS VSS VSS nfet L=0.35U W=2U
Mt1esd_Mclamp_f4 VDDIO VSS VSS VSS nfet L=0.35U W=2U
Mt1esd_Mclamp_f5 VDDIO VSS VSS VSS nfet L=0.35U W=2U
Mt1esd_Mclamp_f6 VDDIO VSS VSS VSS nfet L=0.35U W=2U
Mt1esd_Mclamp_f7 VDDIO VSS VSS VSS nfet L=0.35U W=2U
Mt1esd_Mclamp_f8 VDDIO VSS VSS VSS nfet L=0.35U W=2U
Mt1esd_Mclamp_f9 VDDIO VSS VSS VSS nfet L=0.35U W=2U
Mt1esd_Mclamp_f10 VDDIO VSS VSS VSS nfet L=0.35U W=2U
Mt1esd_Mclamp_f11 VDDIO VSS VSS VSS nfet L=0.35U W=2U
Mt1esd_Mclamp_f12 VDDIO VSS VSS VSS nfet L=0.35U W=2U
Mt1esd_Mclamp_f13 VDDIO VSS VSS VSS nfet L=0.35U W=2U
Mt1esd_Mclamp_f14 VDDIO VSS VSS VSS nfet L=0.35U W=2U
Mt1esd_Mclamp_f15 VDDIO VSS VSS VSS nfet L=0.35U W=2U
Mt1esd_Mclamp_f16 VDDIO VSS VSS VSS nfet L=0.35U W=2U
Mt1esd_Mclamp_f17 VDDIO VSS VSS VSS nfet L=0.35U W=2U
Mt1esd_Mclamp_f18 VDDIO VSS VSS VSS nfet L=0.35U W=2U
Mt1esd_Mclamp_f19 VDDIO VSS VSS VSS nfet L=0.35U W=2U
Xt1esd_Resd PAD$3 PADI_T1 VSS rppd r=164.6 L=1U W=2U
Dt1esd_Dp2 PADI_T1 VDDIO dpantenna A=4P P=8U
Mt1esd_Mn2_f0 PADI_T1 VSS VSS VSS nfet L=0.13U W=1U
Mt1tx_Mi1p_f0 t1tx/OEB OE VDDIO VDDIO pfet L=0.13U W=2U
Mt1tx_Mi1n_f0 t1tx/OEB OE VSS VSS nfet L=0.13U W=1U
Mt1tx_Mnd1p_f0 t1tx/GP DIN$1 VDDIO VDDIO pfet L=0.13U W=2U
Mt1tx_Mnd1p_f1 t1tx/GP DIN$1 VDDIO VDDIO pfet L=0.13U W=2U
Mt1tx_Mnd2p_f0 t1tx/GP OE VDDIO VDDIO pfet L=0.13U W=2U
Mt1tx_Mnd2p_f1 t1tx/GP OE VDDIO VDDIO pfet L=0.13U W=2U
Mt1tx_Mnd1n_f0 t1tx/GP DIN$1 t1tx/NA VSS nfet L=0.13U W=2U
Mt1tx_Mnd1n_f1 t1tx/GP DIN$1 t1tx/NA VSS nfet L=0.13U W=2U
Mt1tx_Mnd2n_f0 t1tx/NA OE VSS VSS nfet L=0.13U W=2U
Mt1tx_Mnd2n_f1 t1tx/NA OE VSS VSS nfet L=0.13U W=2U
Mt1tx_Mnr1p_f0 t1tx/NB DIN$1 VDDIO VDDIO pfet L=0.13U W=2U
Mt1tx_Mnr1p_f1 t1tx/NB DIN$1 VDDIO VDDIO pfet L=0.13U W=2U
Mt1tx_Mnr1p_f2 t1tx/NB DIN$1 VDDIO VDDIO pfet L=0.13U W=2U
Mt1tx_Mnr1p_f3 t1tx/NB DIN$1 VDDIO VDDIO pfet L=0.13U W=2U
Mt1tx_Mnr2p_f0 t1tx/GN t1tx/OEB t1tx/NB VDDIO pfet L=0.13U W=2U
Mt1tx_Mnr2p_f1 t1tx/GN t1tx/OEB t1tx/NB VDDIO pfet L=0.13U W=2U
Mt1tx_Mnr2p_f2 t1tx/GN t1tx/OEB t1tx/NB VDDIO pfet L=0.13U W=2U
Mt1tx_Mnr2p_f3 t1tx/GN t1tx/OEB t1tx/NB VDDIO pfet L=0.13U W=2U
Mt1tx_Mnr1n_f0 t1tx/GN DIN$1 VSS VSS nfet L=0.13U W=1U
Mt1tx_Mnr1n_f1 t1tx/GN DIN$1 VSS VSS nfet L=0.13U W=1U
Mt1tx_Mnr2n_f0 t1tx/GN t1tx/OEB VSS VSS nfet L=0.13U W=1U
Mt1tx_Mnr2n_f1 t1tx/GN t1tx/OEB VSS VSS nfet L=0.13U W=1U
Mt1tx_Mp_f0 t1tx/DP t1tx/GP VDDIO VDDIO pfet L=0.13U W=1U
Mt1tx_Mp_f1 t1tx/DP t1tx/GP VDDIO VDDIO pfet L=0.13U W=1U
Mt1tx_Mp_f2 t1tx/DP t1tx/GP VDDIO VDDIO pfet L=0.13U W=1U
Mt1tx_Mp_f3 t1tx/DP t1tx/GP VDDIO VDDIO pfet L=0.13U W=1U
Mt1tx_Mp_f4 t1tx/DP t1tx/GP VDDIO VDDIO pfet L=0.13U W=1U
Mt1tx_Mp_f5 t1tx/DP t1tx/GP VDDIO VDDIO pfet L=0.13U W=1U
Mt1tx_Mp_f6 t1tx/DP t1tx/GP VDDIO VDDIO pfet L=0.13U W=1U
Mt1tx_Mp_f7 t1tx/DP t1tx/GP VDDIO VDDIO pfet L=0.13U W=1U
Mt1tx_Mp_f8 t1tx/DP t1tx/GP VDDIO VDDIO pfet L=0.13U W=1U
Mt1tx_Mp_f9 t1tx/DP t1tx/GP VDDIO VDDIO pfet L=0.13U W=1U
Mt1tx_Mp_f10 t1tx/DP t1tx/GP VDDIO VDDIO pfet L=0.13U W=1U
Mt1tx_Mp_f11 t1tx/DP t1tx/GP VDDIO VDDIO pfet L=0.13U W=1U
Mt1tx_Mp_f12 t1tx/DP t1tx/GP VDDIO VDDIO pfet L=0.13U W=1U
Mt1tx_Mp_f13 t1tx/DP t1tx/GP VDDIO VDDIO pfet L=0.13U W=1U
Mt1tx_Mp_f14 t1tx/DP t1tx/GP VDDIO VDDIO pfet L=0.13U W=1U
Mt1tx_Mp_f15 t1tx/DP t1tx/GP VDDIO VDDIO pfet L=0.13U W=1U
Mt1tx_Mp_f16 t1tx/DP t1tx/GP VDDIO VDDIO pfet L=0.13U W=1U
Mt1tx_Mp_f17 t1tx/DP t1tx/GP VDDIO VDDIO pfet L=0.13U W=1U
Mt1tx_Mp_f18 t1tx/DP t1tx/GP VDDIO VDDIO pfet L=0.13U W=1U
Mt1tx_Mp_f19 t1tx/DP t1tx/GP VDDIO VDDIO pfet L=0.13U W=1U
Mt1tx_Mp_f20 t1tx/DP t1tx/GP VDDIO VDDIO pfet L=0.13U W=1U
Mt1tx_Mp_f21 t1tx/DP t1tx/GP VDDIO VDDIO pfet L=0.13U W=1U
Mt1tx_Mp_f22 t1tx/DP t1tx/GP VDDIO VDDIO pfet L=0.13U W=1U
Mt1tx_Mp_f23 t1tx/DP t1tx/GP VDDIO VDDIO pfet L=0.13U W=1U
Mt1tx_Mp_f24 t1tx/DP t1tx/GP VDDIO VDDIO pfet L=0.13U W=1U
Mt1tx_Mp_f25 t1tx/DP t1tx/GP VDDIO VDDIO pfet L=0.13U W=1U
Mt1tx_Mp_f26 t1tx/DP t1tx/GP VDDIO VDDIO pfet L=0.13U W=1U
Mt1tx_Mp_f27 t1tx/DP t1tx/GP VDDIO VDDIO pfet L=0.13U W=1U
Mt1tx_Mp_f28 t1tx/DP t1tx/GP VDDIO VDDIO pfet L=0.13U W=1U
Mt1tx_Mp_f29 t1tx/DP t1tx/GP VDDIO VDDIO pfet L=0.13U W=1U
Mt1tx_Mp_f30 t1tx/DP t1tx/GP VDDIO VDDIO pfet L=0.13U W=1U
Mt1tx_Mp_f31 t1tx/DP t1tx/GP VDDIO VDDIO pfet L=0.13U W=1U
Mt1tx_Mp_f32 t1tx/DP t1tx/GP VDDIO VDDIO pfet L=0.13U W=1U
Mt1tx_Mp_f33 t1tx/DP t1tx/GP VDDIO VDDIO pfet L=0.13U W=1U
Mt1tx_Mp_f34 t1tx/DP t1tx/GP VDDIO VDDIO pfet L=0.13U W=1U
Mt1tx_Mp_f35 t1tx/DP t1tx/GP VDDIO VDDIO pfet L=0.13U W=1U
Mt1tx_Mp_f36 t1tx/DP t1tx/GP VDDIO VDDIO pfet L=0.13U W=1U
Mt1tx_Mp_f37 t1tx/DP t1tx/GP VDDIO VDDIO pfet L=0.13U W=1U
Mt1tx_Mp_f38 t1tx/DP t1tx/GP VDDIO VDDIO pfet L=0.13U W=1U
Mt1tx_Mp_f39 t1tx/DP t1tx/GP VDDIO VDDIO pfet L=0.13U W=1U
Mt1tx_Mp_f40 t1tx/DP t1tx/GP VDDIO VDDIO pfet L=0.13U W=1U
Mt1tx_Mp_f41 t1tx/DP t1tx/GP VDDIO VDDIO pfet L=0.13U W=1U
Mt1tx_Mp_f42 t1tx/DP t1tx/GP VDDIO VDDIO pfet L=0.13U W=1U
Mt1tx_Mp_f43 t1tx/DP t1tx/GP VDDIO VDDIO pfet L=0.13U W=1U
Mt1tx_Mp_f44 t1tx/DP t1tx/GP VDDIO VDDIO pfet L=0.13U W=1U
Mt1tx_Mp_f45 t1tx/DP t1tx/GP VDDIO VDDIO pfet L=0.13U W=1U
Mt1tx_Mp_f46 t1tx/DP t1tx/GP VDDIO VDDIO pfet L=0.13U W=1U
Mt1tx_Mp_f47 t1tx/DP t1tx/GP VDDIO VDDIO pfet L=0.13U W=1U
Mt1tx_Mp_f48 t1tx/DP t1tx/GP VDDIO VDDIO pfet L=0.13U W=1U
Mt1tx_Mp_f49 t1tx/DP t1tx/GP VDDIO VDDIO pfet L=0.13U W=1U
Mt1tx_Mp_f50 t1tx/DP t1tx/GP VDDIO VDDIO pfet L=0.13U W=1U
Mt1tx_Mp_f51 t1tx/DP t1tx/GP VDDIO VDDIO pfet L=0.13U W=1U
Mt1tx_Mp_f52 t1tx/DP t1tx/GP VDDIO VDDIO pfet L=0.13U W=1U
Mt1tx_Mp_f53 t1tx/DP t1tx/GP VDDIO VDDIO pfet L=0.13U W=1U
Mt1tx_Mn_f0 t1tx/DN t1tx/GN VSS VSS nfet L=0.13U W=1U
Mt1tx_Mn_f1 t1tx/DN t1tx/GN VSS VSS nfet L=0.13U W=1U
Mt1tx_Mn_f2 t1tx/DN t1tx/GN VSS VSS nfet L=0.13U W=1U
Mt1tx_Mn_f3 t1tx/DN t1tx/GN VSS VSS nfet L=0.13U W=1U
Mt1tx_Mn_f4 t1tx/DN t1tx/GN VSS VSS nfet L=0.13U W=1U
Mt1tx_Mn_f5 t1tx/DN t1tx/GN VSS VSS nfet L=0.13U W=1U
Mt1tx_Mn_f6 t1tx/DN t1tx/GN VSS VSS nfet L=0.13U W=1U
Mt1tx_Mn_f7 t1tx/DN t1tx/GN VSS VSS nfet L=0.13U W=1U
Mt1tx_Mn_f8 t1tx/DN t1tx/GN VSS VSS nfet L=0.13U W=1U
Mt1tx_Mn_f9 t1tx/DN t1tx/GN VSS VSS nfet L=0.13U W=1U
Mt1tx_Mn_f10 t1tx/DN t1tx/GN VSS VSS nfet L=0.13U W=1U
Mt1tx_Mn_f11 t1tx/DN t1tx/GN VSS VSS nfet L=0.13U W=1U
Mt1tx_Mn_f12 t1tx/DN t1tx/GN VSS VSS nfet L=0.13U W=1U
Mt1tx_Mn_f13 t1tx/DN t1tx/GN VSS VSS nfet L=0.13U W=1U
Mt1tx_Mn_f14 t1tx/DN t1tx/GN VSS VSS nfet L=0.13U W=1U
Mt1tx_Mn_f15 t1tx/DN t1tx/GN VSS VSS nfet L=0.13U W=1U
Mt1tx_Mn_f16 t1tx/DN t1tx/GN VSS VSS nfet L=0.13U W=1U
Mt1tx_Mn_f17 t1tx/DN t1tx/GN VSS VSS nfet L=0.13U W=1U
Mt1tx_Mn_f18 t1tx/DN t1tx/GN VSS VSS nfet L=0.13U W=1U
Mt1tx_Mn_f19 t1tx/DN t1tx/GN VSS VSS nfet L=0.13U W=1U
Mt1tx_Mn_f20 t1tx/DN t1tx/GN VSS VSS nfet L=0.13U W=1U
Mt1tx_Mn_f21 t1tx/DN t1tx/GN VSS VSS nfet L=0.13U W=1U
Mt1tx_Mpu_f0 t1tx/PUX PUN VDDIO VDDIO pfet L=0.13U W=2U
Xt1tx_Rpu t1tx/PUX PAD$3 VSS rppd r=12472.0 L=24U W=0.5U
Mt1tx_Mpd_f0 t1tx/PDX PD VSS VSS nfet L=0.13U W=1U
Xt1tx_Rpd PAD$3 t1tx/PDX VSS rppd r=12472.0 L=24U W=0.5U
Xt1tx_Rsp t1tx/DP PAD$3 VSS rppd r=20.0 L=0.5U W=10U
Xt1tx_Rsn t1tx/DN PAD$3 VSS rppd r=20.0 L=0.5U W=10U
Dt2esd_Dp1 PAD$5 VDDIO diodevdd_mod A=35P P=58.08U
Dt2esd_Dp1_dsub VSS VDDIO dsub_2kv_mod A=224.956P P=81.12U
Mt2esd_Mn1_f0 PAD$5 VSS VSS VSS nfet L=0.13U W=2U
Mt2esd_Mn1_f1 PAD$5 VSS VSS VSS nfet L=0.13U W=2U
Mt2esd_Mn1_f2 PAD$5 VSS VSS VSS nfet L=0.13U W=2U
Mt2esd_Mn1_f3 PAD$5 VSS VSS VSS nfet L=0.13U W=2U
Mt2esd_Mn1_f4 PAD$5 VSS VSS VSS nfet L=0.13U W=2U
Mt2esd_Mn1_f5 PAD$5 VSS VSS VSS nfet L=0.13U W=2U
Mt2esd_Mn1_f6 PAD$5 VSS VSS VSS nfet L=0.13U W=2U
Mt2esd_Mn1_f7 PAD$5 VSS VSS VSS nfet L=0.13U W=2U
Mt2esd_Mn1_f8 PAD$5 VSS VSS VSS nfet L=0.13U W=2U
Mt2esd_Mn1_f9 PAD$5 VSS VSS VSS nfet L=0.13U W=2U
Mt2esd_Mclamp_f0 VDDIO VSS VSS VSS nfet L=0.35U W=2U
Mt2esd_Mclamp_f1 VDDIO VSS VSS VSS nfet L=0.35U W=2U
Mt2esd_Mclamp_f2 VDDIO VSS VSS VSS nfet L=0.35U W=2U
Mt2esd_Mclamp_f3 VDDIO VSS VSS VSS nfet L=0.35U W=2U
Mt2esd_Mclamp_f4 VDDIO VSS VSS VSS nfet L=0.35U W=2U
Mt2esd_Mclamp_f5 VDDIO VSS VSS VSS nfet L=0.35U W=2U
Mt2esd_Mclamp_f6 VDDIO VSS VSS VSS nfet L=0.35U W=2U
Mt2esd_Mclamp_f7 VDDIO VSS VSS VSS nfet L=0.35U W=2U
Mt2esd_Mclamp_f8 VDDIO VSS VSS VSS nfet L=0.35U W=2U
Mt2esd_Mclamp_f9 VDDIO VSS VSS VSS nfet L=0.35U W=2U
Mt2esd_Mclamp_f10 VDDIO VSS VSS VSS nfet L=0.35U W=2U
Mt2esd_Mclamp_f11 VDDIO VSS VSS VSS nfet L=0.35U W=2U
Mt2esd_Mclamp_f12 VDDIO VSS VSS VSS nfet L=0.35U W=2U
Mt2esd_Mclamp_f13 VDDIO VSS VSS VSS nfet L=0.35U W=2U
Mt2esd_Mclamp_f14 VDDIO VSS VSS VSS nfet L=0.35U W=2U
Mt2esd_Mclamp_f15 VDDIO VSS VSS VSS nfet L=0.35U W=2U
Mt2esd_Mclamp_f16 VDDIO VSS VSS VSS nfet L=0.35U W=2U
Mt2esd_Mclamp_f17 VDDIO VSS VSS VSS nfet L=0.35U W=2U
Mt2esd_Mclamp_f18 VDDIO VSS VSS VSS nfet L=0.35U W=2U
Mt2esd_Mclamp_f19 VDDIO VSS VSS VSS nfet L=0.35U W=2U
Xt2esd_Resd PAD$5 PADI_T2 VSS rppd r=164.6 L=1U W=2U
Dt2esd_Dp2 PADI_T2 VDDIO dpantenna A=4P P=8U
Mt2esd_Mn2_f0 PADI_T2 VSS VSS VSS nfet L=0.13U W=1U
Mt2tx_Mi1p_f0 t2tx/OEB OE VDDIO VDDIO pfet L=0.13U W=2U
Mt2tx_Mi1n_f0 t2tx/OEB OE VSS VSS nfet L=0.13U W=1U
Mt2tx_Mnd1p_f0 t2tx/GP DIN$2 VDDIO VDDIO pfet L=0.13U W=2U
Mt2tx_Mnd1p_f1 t2tx/GP DIN$2 VDDIO VDDIO pfet L=0.13U W=2U
Mt2tx_Mnd2p_f0 t2tx/GP OE VDDIO VDDIO pfet L=0.13U W=2U
Mt2tx_Mnd2p_f1 t2tx/GP OE VDDIO VDDIO pfet L=0.13U W=2U
Mt2tx_Mnd1n_f0 t2tx/GP DIN$2 t2tx/NA VSS nfet L=0.13U W=2U
Mt2tx_Mnd1n_f1 t2tx/GP DIN$2 t2tx/NA VSS nfet L=0.13U W=2U
Mt2tx_Mnd2n_f0 t2tx/NA OE VSS VSS nfet L=0.13U W=2U
Mt2tx_Mnd2n_f1 t2tx/NA OE VSS VSS nfet L=0.13U W=2U
Mt2tx_Mnr1p_f0 t2tx/NB DIN$2 VDDIO VDDIO pfet L=0.13U W=2U
Mt2tx_Mnr1p_f1 t2tx/NB DIN$2 VDDIO VDDIO pfet L=0.13U W=2U
Mt2tx_Mnr1p_f2 t2tx/NB DIN$2 VDDIO VDDIO pfet L=0.13U W=2U
Mt2tx_Mnr1p_f3 t2tx/NB DIN$2 VDDIO VDDIO pfet L=0.13U W=2U
Mt2tx_Mnr2p_f0 t2tx/GN t2tx/OEB t2tx/NB VDDIO pfet L=0.13U W=2U
Mt2tx_Mnr2p_f1 t2tx/GN t2tx/OEB t2tx/NB VDDIO pfet L=0.13U W=2U
Mt2tx_Mnr2p_f2 t2tx/GN t2tx/OEB t2tx/NB VDDIO pfet L=0.13U W=2U
Mt2tx_Mnr2p_f3 t2tx/GN t2tx/OEB t2tx/NB VDDIO pfet L=0.13U W=2U
Mt2tx_Mnr1n_f0 t2tx/GN DIN$2 VSS VSS nfet L=0.13U W=1U
Mt2tx_Mnr1n_f1 t2tx/GN DIN$2 VSS VSS nfet L=0.13U W=1U
Mt2tx_Mnr2n_f0 t2tx/GN t2tx/OEB VSS VSS nfet L=0.13U W=1U
Mt2tx_Mnr2n_f1 t2tx/GN t2tx/OEB VSS VSS nfet L=0.13U W=1U
Mt2tx_Mp_f0 t2tx/DP t2tx/GP VDDIO VDDIO pfet L=0.13U W=1U
Mt2tx_Mp_f1 t2tx/DP t2tx/GP VDDIO VDDIO pfet L=0.13U W=1U
Mt2tx_Mp_f2 t2tx/DP t2tx/GP VDDIO VDDIO pfet L=0.13U W=1U
Mt2tx_Mp_f3 t2tx/DP t2tx/GP VDDIO VDDIO pfet L=0.13U W=1U
Mt2tx_Mp_f4 t2tx/DP t2tx/GP VDDIO VDDIO pfet L=0.13U W=1U
Mt2tx_Mp_f5 t2tx/DP t2tx/GP VDDIO VDDIO pfet L=0.13U W=1U
Mt2tx_Mp_f6 t2tx/DP t2tx/GP VDDIO VDDIO pfet L=0.13U W=1U
Mt2tx_Mp_f7 t2tx/DP t2tx/GP VDDIO VDDIO pfet L=0.13U W=1U
Mt2tx_Mp_f8 t2tx/DP t2tx/GP VDDIO VDDIO pfet L=0.13U W=1U
Mt2tx_Mp_f9 t2tx/DP t2tx/GP VDDIO VDDIO pfet L=0.13U W=1U
Mt2tx_Mp_f10 t2tx/DP t2tx/GP VDDIO VDDIO pfet L=0.13U W=1U
Mt2tx_Mp_f11 t2tx/DP t2tx/GP VDDIO VDDIO pfet L=0.13U W=1U
Mt2tx_Mp_f12 t2tx/DP t2tx/GP VDDIO VDDIO pfet L=0.13U W=1U
Mt2tx_Mp_f13 t2tx/DP t2tx/GP VDDIO VDDIO pfet L=0.13U W=1U
Mt2tx_Mp_f14 t2tx/DP t2tx/GP VDDIO VDDIO pfet L=0.13U W=1U
Mt2tx_Mp_f15 t2tx/DP t2tx/GP VDDIO VDDIO pfet L=0.13U W=1U
Mt2tx_Mp_f16 t2tx/DP t2tx/GP VDDIO VDDIO pfet L=0.13U W=1U
Mt2tx_Mp_f17 t2tx/DP t2tx/GP VDDIO VDDIO pfet L=0.13U W=1U
Mt2tx_Mp_f18 t2tx/DP t2tx/GP VDDIO VDDIO pfet L=0.13U W=1U
Mt2tx_Mp_f19 t2tx/DP t2tx/GP VDDIO VDDIO pfet L=0.13U W=1U
Mt2tx_Mp_f20 t2tx/DP t2tx/GP VDDIO VDDIO pfet L=0.13U W=1U
Mt2tx_Mp_f21 t2tx/DP t2tx/GP VDDIO VDDIO pfet L=0.13U W=1U
Mt2tx_Mp_f22 t2tx/DP t2tx/GP VDDIO VDDIO pfet L=0.13U W=1U
Mt2tx_Mp_f23 t2tx/DP t2tx/GP VDDIO VDDIO pfet L=0.13U W=1U
Mt2tx_Mp_f24 t2tx/DP t2tx/GP VDDIO VDDIO pfet L=0.13U W=1U
Mt2tx_Mp_f25 t2tx/DP t2tx/GP VDDIO VDDIO pfet L=0.13U W=1U
Mt2tx_Mp_f26 t2tx/DP t2tx/GP VDDIO VDDIO pfet L=0.13U W=1U
Mt2tx_Mp_f27 t2tx/DP t2tx/GP VDDIO VDDIO pfet L=0.13U W=1U
Mt2tx_Mp_f28 t2tx/DP t2tx/GP VDDIO VDDIO pfet L=0.13U W=1U
Mt2tx_Mp_f29 t2tx/DP t2tx/GP VDDIO VDDIO pfet L=0.13U W=1U
Mt2tx_Mp_f30 t2tx/DP t2tx/GP VDDIO VDDIO pfet L=0.13U W=1U
Mt2tx_Mp_f31 t2tx/DP t2tx/GP VDDIO VDDIO pfet L=0.13U W=1U
Mt2tx_Mp_f32 t2tx/DP t2tx/GP VDDIO VDDIO pfet L=0.13U W=1U
Mt2tx_Mp_f33 t2tx/DP t2tx/GP VDDIO VDDIO pfet L=0.13U W=1U
Mt2tx_Mp_f34 t2tx/DP t2tx/GP VDDIO VDDIO pfet L=0.13U W=1U
Mt2tx_Mp_f35 t2tx/DP t2tx/GP VDDIO VDDIO pfet L=0.13U W=1U
Mt2tx_Mp_f36 t2tx/DP t2tx/GP VDDIO VDDIO pfet L=0.13U W=1U
Mt2tx_Mp_f37 t2tx/DP t2tx/GP VDDIO VDDIO pfet L=0.13U W=1U
Mt2tx_Mp_f38 t2tx/DP t2tx/GP VDDIO VDDIO pfet L=0.13U W=1U
Mt2tx_Mp_f39 t2tx/DP t2tx/GP VDDIO VDDIO pfet L=0.13U W=1U
Mt2tx_Mp_f40 t2tx/DP t2tx/GP VDDIO VDDIO pfet L=0.13U W=1U
Mt2tx_Mp_f41 t2tx/DP t2tx/GP VDDIO VDDIO pfet L=0.13U W=1U
Mt2tx_Mp_f42 t2tx/DP t2tx/GP VDDIO VDDIO pfet L=0.13U W=1U
Mt2tx_Mp_f43 t2tx/DP t2tx/GP VDDIO VDDIO pfet L=0.13U W=1U
Mt2tx_Mp_f44 t2tx/DP t2tx/GP VDDIO VDDIO pfet L=0.13U W=1U
Mt2tx_Mp_f45 t2tx/DP t2tx/GP VDDIO VDDIO pfet L=0.13U W=1U
Mt2tx_Mp_f46 t2tx/DP t2tx/GP VDDIO VDDIO pfet L=0.13U W=1U
Mt2tx_Mp_f47 t2tx/DP t2tx/GP VDDIO VDDIO pfet L=0.13U W=1U
Mt2tx_Mp_f48 t2tx/DP t2tx/GP VDDIO VDDIO pfet L=0.13U W=1U
Mt2tx_Mp_f49 t2tx/DP t2tx/GP VDDIO VDDIO pfet L=0.13U W=1U
Mt2tx_Mp_f50 t2tx/DP t2tx/GP VDDIO VDDIO pfet L=0.13U W=1U
Mt2tx_Mp_f51 t2tx/DP t2tx/GP VDDIO VDDIO pfet L=0.13U W=1U
Mt2tx_Mp_f52 t2tx/DP t2tx/GP VDDIO VDDIO pfet L=0.13U W=1U
Mt2tx_Mp_f53 t2tx/DP t2tx/GP VDDIO VDDIO pfet L=0.13U W=1U
Mt2tx_Mn_f0 t2tx/DN t2tx/GN VSS VSS nfet L=0.13U W=1U
Mt2tx_Mn_f1 t2tx/DN t2tx/GN VSS VSS nfet L=0.13U W=1U
Mt2tx_Mn_f2 t2tx/DN t2tx/GN VSS VSS nfet L=0.13U W=1U
Mt2tx_Mn_f3 t2tx/DN t2tx/GN VSS VSS nfet L=0.13U W=1U
Mt2tx_Mn_f4 t2tx/DN t2tx/GN VSS VSS nfet L=0.13U W=1U
Mt2tx_Mn_f5 t2tx/DN t2tx/GN VSS VSS nfet L=0.13U W=1U
Mt2tx_Mn_f6 t2tx/DN t2tx/GN VSS VSS nfet L=0.13U W=1U
Mt2tx_Mn_f7 t2tx/DN t2tx/GN VSS VSS nfet L=0.13U W=1U
Mt2tx_Mn_f8 t2tx/DN t2tx/GN VSS VSS nfet L=0.13U W=1U
Mt2tx_Mn_f9 t2tx/DN t2tx/GN VSS VSS nfet L=0.13U W=1U
Mt2tx_Mn_f10 t2tx/DN t2tx/GN VSS VSS nfet L=0.13U W=1U
Mt2tx_Mn_f11 t2tx/DN t2tx/GN VSS VSS nfet L=0.13U W=1U
Mt2tx_Mn_f12 t2tx/DN t2tx/GN VSS VSS nfet L=0.13U W=1U
Mt2tx_Mn_f13 t2tx/DN t2tx/GN VSS VSS nfet L=0.13U W=1U
Mt2tx_Mn_f14 t2tx/DN t2tx/GN VSS VSS nfet L=0.13U W=1U
Mt2tx_Mn_f15 t2tx/DN t2tx/GN VSS VSS nfet L=0.13U W=1U
Mt2tx_Mn_f16 t2tx/DN t2tx/GN VSS VSS nfet L=0.13U W=1U
Mt2tx_Mn_f17 t2tx/DN t2tx/GN VSS VSS nfet L=0.13U W=1U
Mt2tx_Mn_f18 t2tx/DN t2tx/GN VSS VSS nfet L=0.13U W=1U
Mt2tx_Mn_f19 t2tx/DN t2tx/GN VSS VSS nfet L=0.13U W=1U
Mt2tx_Mn_f20 t2tx/DN t2tx/GN VSS VSS nfet L=0.13U W=1U
Mt2tx_Mn_f21 t2tx/DN t2tx/GN VSS VSS nfet L=0.13U W=1U
Mt2tx_Mpu_f0 t2tx/PUX PUN VDDIO VDDIO pfet L=0.13U W=2U
Xt2tx_Rpu t2tx/PUX PAD$5 VSS rppd r=12472.0 L=24U W=0.5U
Mt2tx_Mpd_f0 t2tx/PDX PD VSS VSS nfet L=0.13U W=1U
Xt2tx_Rpd PAD$5 t2tx/PDX VSS rppd r=12472.0 L=24U W=0.5U
Xt2tx_Rsp t2tx/DP PAD$5 VSS rppd r=20.0 L=0.5U W=10U
Xt2tx_Rsn t2tx/DN PAD$5 VSS rppd r=20.0 L=0.5U W=10U
Dt3esd_Dp1 PAD$7 VDDIO diodevdd_mod A=35P P=58.08U
Dt3esd_Dp1_dsub VSS VDDIO dsub_2kv_mod A=224.956P P=81.12U
Mt3esd_Mn1_f0 PAD$7 VSS VSS VSS nfet L=0.13U W=2U
Mt3esd_Mn1_f1 PAD$7 VSS VSS VSS nfet L=0.13U W=2U
Mt3esd_Mn1_f2 PAD$7 VSS VSS VSS nfet L=0.13U W=2U
Mt3esd_Mn1_f3 PAD$7 VSS VSS VSS nfet L=0.13U W=2U
Mt3esd_Mn1_f4 PAD$7 VSS VSS VSS nfet L=0.13U W=2U
Mt3esd_Mn1_f5 PAD$7 VSS VSS VSS nfet L=0.13U W=2U
Mt3esd_Mn1_f6 PAD$7 VSS VSS VSS nfet L=0.13U W=2U
Mt3esd_Mn1_f7 PAD$7 VSS VSS VSS nfet L=0.13U W=2U
Mt3esd_Mn1_f8 PAD$7 VSS VSS VSS nfet L=0.13U W=2U
Mt3esd_Mn1_f9 PAD$7 VSS VSS VSS nfet L=0.13U W=2U
Mt3esd_Mclamp_f0 VDDIO VSS VSS VSS nfet L=0.35U W=2U
Mt3esd_Mclamp_f1 VDDIO VSS VSS VSS nfet L=0.35U W=2U
Mt3esd_Mclamp_f2 VDDIO VSS VSS VSS nfet L=0.35U W=2U
Mt3esd_Mclamp_f3 VDDIO VSS VSS VSS nfet L=0.35U W=2U
Mt3esd_Mclamp_f4 VDDIO VSS VSS VSS nfet L=0.35U W=2U
Mt3esd_Mclamp_f5 VDDIO VSS VSS VSS nfet L=0.35U W=2U
Mt3esd_Mclamp_f6 VDDIO VSS VSS VSS nfet L=0.35U W=2U
Mt3esd_Mclamp_f7 VDDIO VSS VSS VSS nfet L=0.35U W=2U
Mt3esd_Mclamp_f8 VDDIO VSS VSS VSS nfet L=0.35U W=2U
Mt3esd_Mclamp_f9 VDDIO VSS VSS VSS nfet L=0.35U W=2U
Mt3esd_Mclamp_f10 VDDIO VSS VSS VSS nfet L=0.35U W=2U
Mt3esd_Mclamp_f11 VDDIO VSS VSS VSS nfet L=0.35U W=2U
Mt3esd_Mclamp_f12 VDDIO VSS VSS VSS nfet L=0.35U W=2U
Mt3esd_Mclamp_f13 VDDIO VSS VSS VSS nfet L=0.35U W=2U
Mt3esd_Mclamp_f14 VDDIO VSS VSS VSS nfet L=0.35U W=2U
Mt3esd_Mclamp_f15 VDDIO VSS VSS VSS nfet L=0.35U W=2U
Mt3esd_Mclamp_f16 VDDIO VSS VSS VSS nfet L=0.35U W=2U
Mt3esd_Mclamp_f17 VDDIO VSS VSS VSS nfet L=0.35U W=2U
Mt3esd_Mclamp_f18 VDDIO VSS VSS VSS nfet L=0.35U W=2U
Mt3esd_Mclamp_f19 VDDIO VSS VSS VSS nfet L=0.35U W=2U
Xt3esd_Resd PAD$7 PADI_T3 VSS rppd r=164.6 L=1U W=2U
Dt3esd_Dp2 PADI_T3 VDDIO dpantenna A=4P P=8U
Mt3esd_Mn2_f0 PADI_T3 VSS VSS VSS nfet L=0.13U W=1U
Mt3tx_Mi1p_f0 t3tx/OEB OE VDDIO VDDIO pfet L=0.13U W=2U
Mt3tx_Mi1n_f0 t3tx/OEB OE VSS VSS nfet L=0.13U W=1U
Mt3tx_Mnd1p_f0 t3tx/GP DIN$3 VDDIO VDDIO pfet L=0.13U W=2U
Mt3tx_Mnd1p_f1 t3tx/GP DIN$3 VDDIO VDDIO pfet L=0.13U W=2U
Mt3tx_Mnd2p_f0 t3tx/GP OE VDDIO VDDIO pfet L=0.13U W=2U
Mt3tx_Mnd2p_f1 t3tx/GP OE VDDIO VDDIO pfet L=0.13U W=2U
Mt3tx_Mnd1n_f0 t3tx/GP DIN$3 t3tx/NA VSS nfet L=0.13U W=2U
Mt3tx_Mnd1n_f1 t3tx/GP DIN$3 t3tx/NA VSS nfet L=0.13U W=2U
Mt3tx_Mnd2n_f0 t3tx/NA OE VSS VSS nfet L=0.13U W=2U
Mt3tx_Mnd2n_f1 t3tx/NA OE VSS VSS nfet L=0.13U W=2U
Mt3tx_Mnr1p_f0 t3tx/NB DIN$3 VDDIO VDDIO pfet L=0.13U W=2U
Mt3tx_Mnr1p_f1 t3tx/NB DIN$3 VDDIO VDDIO pfet L=0.13U W=2U
Mt3tx_Mnr1p_f2 t3tx/NB DIN$3 VDDIO VDDIO pfet L=0.13U W=2U
Mt3tx_Mnr1p_f3 t3tx/NB DIN$3 VDDIO VDDIO pfet L=0.13U W=2U
Mt3tx_Mnr2p_f0 t3tx/GN t3tx/OEB t3tx/NB VDDIO pfet L=0.13U W=2U
Mt3tx_Mnr2p_f1 t3tx/GN t3tx/OEB t3tx/NB VDDIO pfet L=0.13U W=2U
Mt3tx_Mnr2p_f2 t3tx/GN t3tx/OEB t3tx/NB VDDIO pfet L=0.13U W=2U
Mt3tx_Mnr2p_f3 t3tx/GN t3tx/OEB t3tx/NB VDDIO pfet L=0.13U W=2U
Mt3tx_Mnr1n_f0 t3tx/GN DIN$3 VSS VSS nfet L=0.13U W=1U
Mt3tx_Mnr1n_f1 t3tx/GN DIN$3 VSS VSS nfet L=0.13U W=1U
Mt3tx_Mnr2n_f0 t3tx/GN t3tx/OEB VSS VSS nfet L=0.13U W=1U
Mt3tx_Mnr2n_f1 t3tx/GN t3tx/OEB VSS VSS nfet L=0.13U W=1U
Mt3tx_Mp_f0 t3tx/DP t3tx/GP VDDIO VDDIO pfet L=0.13U W=1U
Mt3tx_Mp_f1 t3tx/DP t3tx/GP VDDIO VDDIO pfet L=0.13U W=1U
Mt3tx_Mp_f2 t3tx/DP t3tx/GP VDDIO VDDIO pfet L=0.13U W=1U
Mt3tx_Mp_f3 t3tx/DP t3tx/GP VDDIO VDDIO pfet L=0.13U W=1U
Mt3tx_Mp_f4 t3tx/DP t3tx/GP VDDIO VDDIO pfet L=0.13U W=1U
Mt3tx_Mp_f5 t3tx/DP t3tx/GP VDDIO VDDIO pfet L=0.13U W=1U
Mt3tx_Mp_f6 t3tx/DP t3tx/GP VDDIO VDDIO pfet L=0.13U W=1U
Mt3tx_Mp_f7 t3tx/DP t3tx/GP VDDIO VDDIO pfet L=0.13U W=1U
Mt3tx_Mp_f8 t3tx/DP t3tx/GP VDDIO VDDIO pfet L=0.13U W=1U
Mt3tx_Mp_f9 t3tx/DP t3tx/GP VDDIO VDDIO pfet L=0.13U W=1U
Mt3tx_Mp_f10 t3tx/DP t3tx/GP VDDIO VDDIO pfet L=0.13U W=1U
Mt3tx_Mp_f11 t3tx/DP t3tx/GP VDDIO VDDIO pfet L=0.13U W=1U
Mt3tx_Mp_f12 t3tx/DP t3tx/GP VDDIO VDDIO pfet L=0.13U W=1U
Mt3tx_Mp_f13 t3tx/DP t3tx/GP VDDIO VDDIO pfet L=0.13U W=1U
Mt3tx_Mp_f14 t3tx/DP t3tx/GP VDDIO VDDIO pfet L=0.13U W=1U
Mt3tx_Mp_f15 t3tx/DP t3tx/GP VDDIO VDDIO pfet L=0.13U W=1U
Mt3tx_Mp_f16 t3tx/DP t3tx/GP VDDIO VDDIO pfet L=0.13U W=1U
Mt3tx_Mp_f17 t3tx/DP t3tx/GP VDDIO VDDIO pfet L=0.13U W=1U
Mt3tx_Mp_f18 t3tx/DP t3tx/GP VDDIO VDDIO pfet L=0.13U W=1U
Mt3tx_Mp_f19 t3tx/DP t3tx/GP VDDIO VDDIO pfet L=0.13U W=1U
Mt3tx_Mp_f20 t3tx/DP t3tx/GP VDDIO VDDIO pfet L=0.13U W=1U
Mt3tx_Mp_f21 t3tx/DP t3tx/GP VDDIO VDDIO pfet L=0.13U W=1U
Mt3tx_Mp_f22 t3tx/DP t3tx/GP VDDIO VDDIO pfet L=0.13U W=1U
Mt3tx_Mp_f23 t3tx/DP t3tx/GP VDDIO VDDIO pfet L=0.13U W=1U
Mt3tx_Mp_f24 t3tx/DP t3tx/GP VDDIO VDDIO pfet L=0.13U W=1U
Mt3tx_Mp_f25 t3tx/DP t3tx/GP VDDIO VDDIO pfet L=0.13U W=1U
Mt3tx_Mp_f26 t3tx/DP t3tx/GP VDDIO VDDIO pfet L=0.13U W=1U
Mt3tx_Mp_f27 t3tx/DP t3tx/GP VDDIO VDDIO pfet L=0.13U W=1U
Mt3tx_Mp_f28 t3tx/DP t3tx/GP VDDIO VDDIO pfet L=0.13U W=1U
Mt3tx_Mp_f29 t3tx/DP t3tx/GP VDDIO VDDIO pfet L=0.13U W=1U
Mt3tx_Mp_f30 t3tx/DP t3tx/GP VDDIO VDDIO pfet L=0.13U W=1U
Mt3tx_Mp_f31 t3tx/DP t3tx/GP VDDIO VDDIO pfet L=0.13U W=1U
Mt3tx_Mp_f32 t3tx/DP t3tx/GP VDDIO VDDIO pfet L=0.13U W=1U
Mt3tx_Mp_f33 t3tx/DP t3tx/GP VDDIO VDDIO pfet L=0.13U W=1U
Mt3tx_Mp_f34 t3tx/DP t3tx/GP VDDIO VDDIO pfet L=0.13U W=1U
Mt3tx_Mp_f35 t3tx/DP t3tx/GP VDDIO VDDIO pfet L=0.13U W=1U
Mt3tx_Mp_f36 t3tx/DP t3tx/GP VDDIO VDDIO pfet L=0.13U W=1U
Mt3tx_Mp_f37 t3tx/DP t3tx/GP VDDIO VDDIO pfet L=0.13U W=1U
Mt3tx_Mp_f38 t3tx/DP t3tx/GP VDDIO VDDIO pfet L=0.13U W=1U
Mt3tx_Mp_f39 t3tx/DP t3tx/GP VDDIO VDDIO pfet L=0.13U W=1U
Mt3tx_Mp_f40 t3tx/DP t3tx/GP VDDIO VDDIO pfet L=0.13U W=1U
Mt3tx_Mp_f41 t3tx/DP t3tx/GP VDDIO VDDIO pfet L=0.13U W=1U
Mt3tx_Mp_f42 t3tx/DP t3tx/GP VDDIO VDDIO pfet L=0.13U W=1U
Mt3tx_Mp_f43 t3tx/DP t3tx/GP VDDIO VDDIO pfet L=0.13U W=1U
Mt3tx_Mp_f44 t3tx/DP t3tx/GP VDDIO VDDIO pfet L=0.13U W=1U
Mt3tx_Mp_f45 t3tx/DP t3tx/GP VDDIO VDDIO pfet L=0.13U W=1U
Mt3tx_Mp_f46 t3tx/DP t3tx/GP VDDIO VDDIO pfet L=0.13U W=1U
Mt3tx_Mp_f47 t3tx/DP t3tx/GP VDDIO VDDIO pfet L=0.13U W=1U
Mt3tx_Mp_f48 t3tx/DP t3tx/GP VDDIO VDDIO pfet L=0.13U W=1U
Mt3tx_Mp_f49 t3tx/DP t3tx/GP VDDIO VDDIO pfet L=0.13U W=1U
Mt3tx_Mp_f50 t3tx/DP t3tx/GP VDDIO VDDIO pfet L=0.13U W=1U
Mt3tx_Mp_f51 t3tx/DP t3tx/GP VDDIO VDDIO pfet L=0.13U W=1U
Mt3tx_Mp_f52 t3tx/DP t3tx/GP VDDIO VDDIO pfet L=0.13U W=1U
Mt3tx_Mp_f53 t3tx/DP t3tx/GP VDDIO VDDIO pfet L=0.13U W=1U
Mt3tx_Mn_f0 t3tx/DN t3tx/GN VSS VSS nfet L=0.13U W=1U
Mt3tx_Mn_f1 t3tx/DN t3tx/GN VSS VSS nfet L=0.13U W=1U
Mt3tx_Mn_f2 t3tx/DN t3tx/GN VSS VSS nfet L=0.13U W=1U
Mt3tx_Mn_f3 t3tx/DN t3tx/GN VSS VSS nfet L=0.13U W=1U
Mt3tx_Mn_f4 t3tx/DN t3tx/GN VSS VSS nfet L=0.13U W=1U
Mt3tx_Mn_f5 t3tx/DN t3tx/GN VSS VSS nfet L=0.13U W=1U
Mt3tx_Mn_f6 t3tx/DN t3tx/GN VSS VSS nfet L=0.13U W=1U
Mt3tx_Mn_f7 t3tx/DN t3tx/GN VSS VSS nfet L=0.13U W=1U
Mt3tx_Mn_f8 t3tx/DN t3tx/GN VSS VSS nfet L=0.13U W=1U
Mt3tx_Mn_f9 t3tx/DN t3tx/GN VSS VSS nfet L=0.13U W=1U
Mt3tx_Mn_f10 t3tx/DN t3tx/GN VSS VSS nfet L=0.13U W=1U
Mt3tx_Mn_f11 t3tx/DN t3tx/GN VSS VSS nfet L=0.13U W=1U
Mt3tx_Mn_f12 t3tx/DN t3tx/GN VSS VSS nfet L=0.13U W=1U
Mt3tx_Mn_f13 t3tx/DN t3tx/GN VSS VSS nfet L=0.13U W=1U
Mt3tx_Mn_f14 t3tx/DN t3tx/GN VSS VSS nfet L=0.13U W=1U
Mt3tx_Mn_f15 t3tx/DN t3tx/GN VSS VSS nfet L=0.13U W=1U
Mt3tx_Mn_f16 t3tx/DN t3tx/GN VSS VSS nfet L=0.13U W=1U
Mt3tx_Mn_f17 t3tx/DN t3tx/GN VSS VSS nfet L=0.13U W=1U
Mt3tx_Mn_f18 t3tx/DN t3tx/GN VSS VSS nfet L=0.13U W=1U
Mt3tx_Mn_f19 t3tx/DN t3tx/GN VSS VSS nfet L=0.13U W=1U
Mt3tx_Mn_f20 t3tx/DN t3tx/GN VSS VSS nfet L=0.13U W=1U
Mt3tx_Mn_f21 t3tx/DN t3tx/GN VSS VSS nfet L=0.13U W=1U
Mt3tx_Mpu_f0 t3tx/PUX PUN VDDIO VDDIO pfet L=0.13U W=2U
Xt3tx_Rpu t3tx/PUX PAD$7 VSS rppd r=12472.0 L=24U W=0.5U
Mt3tx_Mpd_f0 t3tx/PDX PD VSS VSS nfet L=0.13U W=1U
Xt3tx_Rpd PAD$7 t3tx/PDX VSS rppd r=12472.0 L=24U W=0.5U
Xt3tx_Rsp t3tx/DP PAD$7 VSS rppd r=20.0 L=0.5U W=10U
Xt3tx_Rsn t3tx/DN PAD$7 VSS rppd r=20.0 L=0.5U W=10U
Dt4esd_Dp1 PAD$9 VDDIO diodevdd_mod A=35P P=58.08U
Dt4esd_Dp1_dsub VSS VDDIO dsub_2kv_mod A=224.956P P=81.12U
Mt4esd_Mn1_f0 PAD$9 VSS VSS VSS nfet L=0.13U W=2U
Mt4esd_Mn1_f1 PAD$9 VSS VSS VSS nfet L=0.13U W=2U
Mt4esd_Mn1_f2 PAD$9 VSS VSS VSS nfet L=0.13U W=2U
Mt4esd_Mn1_f3 PAD$9 VSS VSS VSS nfet L=0.13U W=2U
Mt4esd_Mn1_f4 PAD$9 VSS VSS VSS nfet L=0.13U W=2U
Mt4esd_Mn1_f5 PAD$9 VSS VSS VSS nfet L=0.13U W=2U
Mt4esd_Mn1_f6 PAD$9 VSS VSS VSS nfet L=0.13U W=2U
Mt4esd_Mn1_f7 PAD$9 VSS VSS VSS nfet L=0.13U W=2U
Mt4esd_Mn1_f8 PAD$9 VSS VSS VSS nfet L=0.13U W=2U
Mt4esd_Mn1_f9 PAD$9 VSS VSS VSS nfet L=0.13U W=2U
Mt4esd_Mclamp_f0 VDDIO VSS VSS VSS nfet L=0.35U W=2U
Mt4esd_Mclamp_f1 VDDIO VSS VSS VSS nfet L=0.35U W=2U
Mt4esd_Mclamp_f2 VDDIO VSS VSS VSS nfet L=0.35U W=2U
Mt4esd_Mclamp_f3 VDDIO VSS VSS VSS nfet L=0.35U W=2U
Mt4esd_Mclamp_f4 VDDIO VSS VSS VSS nfet L=0.35U W=2U
Mt4esd_Mclamp_f5 VDDIO VSS VSS VSS nfet L=0.35U W=2U
Mt4esd_Mclamp_f6 VDDIO VSS VSS VSS nfet L=0.35U W=2U
Mt4esd_Mclamp_f7 VDDIO VSS VSS VSS nfet L=0.35U W=2U
Mt4esd_Mclamp_f8 VDDIO VSS VSS VSS nfet L=0.35U W=2U
Mt4esd_Mclamp_f9 VDDIO VSS VSS VSS nfet L=0.35U W=2U
Mt4esd_Mclamp_f10 VDDIO VSS VSS VSS nfet L=0.35U W=2U
Mt4esd_Mclamp_f11 VDDIO VSS VSS VSS nfet L=0.35U W=2U
Mt4esd_Mclamp_f12 VDDIO VSS VSS VSS nfet L=0.35U W=2U
Mt4esd_Mclamp_f13 VDDIO VSS VSS VSS nfet L=0.35U W=2U
Mt4esd_Mclamp_f14 VDDIO VSS VSS VSS nfet L=0.35U W=2U
Mt4esd_Mclamp_f15 VDDIO VSS VSS VSS nfet L=0.35U W=2U
Mt4esd_Mclamp_f16 VDDIO VSS VSS VSS nfet L=0.35U W=2U
Mt4esd_Mclamp_f17 VDDIO VSS VSS VSS nfet L=0.35U W=2U
Mt4esd_Mclamp_f18 VDDIO VSS VSS VSS nfet L=0.35U W=2U
Mt4esd_Mclamp_f19 VDDIO VSS VSS VSS nfet L=0.35U W=2U
Xt4esd_Resd PAD$9 PADI_T4 VSS rppd r=164.6 L=1U W=2U
Dt4esd_Dp2 PADI_T4 VDDIO dpantenna A=4P P=8U
Mt4esd_Mn2_f0 PADI_T4 VSS VSS VSS nfet L=0.13U W=1U
Mt4tx_Mi1p_f0 t4tx/OEB OE VDDIO VDDIO pfet L=0.13U W=2U
Mt4tx_Mi1n_f0 t4tx/OEB OE VSS VSS nfet L=0.13U W=1U
Mt4tx_Mnd1p_f0 t4tx/GP DIN$4 VDDIO VDDIO pfet L=0.13U W=2U
Mt4tx_Mnd1p_f1 t4tx/GP DIN$4 VDDIO VDDIO pfet L=0.13U W=2U
Mt4tx_Mnd2p_f0 t4tx/GP OE VDDIO VDDIO pfet L=0.13U W=2U
Mt4tx_Mnd2p_f1 t4tx/GP OE VDDIO VDDIO pfet L=0.13U W=2U
Mt4tx_Mnd1n_f0 t4tx/GP DIN$4 t4tx/NA VSS nfet L=0.13U W=2U
Mt4tx_Mnd1n_f1 t4tx/GP DIN$4 t4tx/NA VSS nfet L=0.13U W=2U
Mt4tx_Mnd2n_f0 t4tx/NA OE VSS VSS nfet L=0.13U W=2U
Mt4tx_Mnd2n_f1 t4tx/NA OE VSS VSS nfet L=0.13U W=2U
Mt4tx_Mnr1p_f0 t4tx/NB DIN$4 VDDIO VDDIO pfet L=0.13U W=2U
Mt4tx_Mnr1p_f1 t4tx/NB DIN$4 VDDIO VDDIO pfet L=0.13U W=2U
Mt4tx_Mnr1p_f2 t4tx/NB DIN$4 VDDIO VDDIO pfet L=0.13U W=2U
Mt4tx_Mnr1p_f3 t4tx/NB DIN$4 VDDIO VDDIO pfet L=0.13U W=2U
Mt4tx_Mnr2p_f0 t4tx/GN t4tx/OEB t4tx/NB VDDIO pfet L=0.13U W=2U
Mt4tx_Mnr2p_f1 t4tx/GN t4tx/OEB t4tx/NB VDDIO pfet L=0.13U W=2U
Mt4tx_Mnr2p_f2 t4tx/GN t4tx/OEB t4tx/NB VDDIO pfet L=0.13U W=2U
Mt4tx_Mnr2p_f3 t4tx/GN t4tx/OEB t4tx/NB VDDIO pfet L=0.13U W=2U
Mt4tx_Mnr1n_f0 t4tx/GN DIN$4 VSS VSS nfet L=0.13U W=1U
Mt4tx_Mnr1n_f1 t4tx/GN DIN$4 VSS VSS nfet L=0.13U W=1U
Mt4tx_Mnr2n_f0 t4tx/GN t4tx/OEB VSS VSS nfet L=0.13U W=1U
Mt4tx_Mnr2n_f1 t4tx/GN t4tx/OEB VSS VSS nfet L=0.13U W=1U
Mt4tx_Mp_f0 t4tx/DP t4tx/GP VDDIO VDDIO pfet L=0.13U W=1U
Mt4tx_Mp_f1 t4tx/DP t4tx/GP VDDIO VDDIO pfet L=0.13U W=1U
Mt4tx_Mp_f2 t4tx/DP t4tx/GP VDDIO VDDIO pfet L=0.13U W=1U
Mt4tx_Mp_f3 t4tx/DP t4tx/GP VDDIO VDDIO pfet L=0.13U W=1U
Mt4tx_Mp_f4 t4tx/DP t4tx/GP VDDIO VDDIO pfet L=0.13U W=1U
Mt4tx_Mp_f5 t4tx/DP t4tx/GP VDDIO VDDIO pfet L=0.13U W=1U
Mt4tx_Mp_f6 t4tx/DP t4tx/GP VDDIO VDDIO pfet L=0.13U W=1U
Mt4tx_Mp_f7 t4tx/DP t4tx/GP VDDIO VDDIO pfet L=0.13U W=1U
Mt4tx_Mp_f8 t4tx/DP t4tx/GP VDDIO VDDIO pfet L=0.13U W=1U
Mt4tx_Mp_f9 t4tx/DP t4tx/GP VDDIO VDDIO pfet L=0.13U W=1U
Mt4tx_Mp_f10 t4tx/DP t4tx/GP VDDIO VDDIO pfet L=0.13U W=1U
Mt4tx_Mp_f11 t4tx/DP t4tx/GP VDDIO VDDIO pfet L=0.13U W=1U
Mt4tx_Mp_f12 t4tx/DP t4tx/GP VDDIO VDDIO pfet L=0.13U W=1U
Mt4tx_Mp_f13 t4tx/DP t4tx/GP VDDIO VDDIO pfet L=0.13U W=1U
Mt4tx_Mp_f14 t4tx/DP t4tx/GP VDDIO VDDIO pfet L=0.13U W=1U
Mt4tx_Mp_f15 t4tx/DP t4tx/GP VDDIO VDDIO pfet L=0.13U W=1U
Mt4tx_Mp_f16 t4tx/DP t4tx/GP VDDIO VDDIO pfet L=0.13U W=1U
Mt4tx_Mp_f17 t4tx/DP t4tx/GP VDDIO VDDIO pfet L=0.13U W=1U
Mt4tx_Mp_f18 t4tx/DP t4tx/GP VDDIO VDDIO pfet L=0.13U W=1U
Mt4tx_Mp_f19 t4tx/DP t4tx/GP VDDIO VDDIO pfet L=0.13U W=1U
Mt4tx_Mp_f20 t4tx/DP t4tx/GP VDDIO VDDIO pfet L=0.13U W=1U
Mt4tx_Mp_f21 t4tx/DP t4tx/GP VDDIO VDDIO pfet L=0.13U W=1U
Mt4tx_Mp_f22 t4tx/DP t4tx/GP VDDIO VDDIO pfet L=0.13U W=1U
Mt4tx_Mp_f23 t4tx/DP t4tx/GP VDDIO VDDIO pfet L=0.13U W=1U
Mt4tx_Mp_f24 t4tx/DP t4tx/GP VDDIO VDDIO pfet L=0.13U W=1U
Mt4tx_Mp_f25 t4tx/DP t4tx/GP VDDIO VDDIO pfet L=0.13U W=1U
Mt4tx_Mp_f26 t4tx/DP t4tx/GP VDDIO VDDIO pfet L=0.13U W=1U
Mt4tx_Mp_f27 t4tx/DP t4tx/GP VDDIO VDDIO pfet L=0.13U W=1U
Mt4tx_Mp_f28 t4tx/DP t4tx/GP VDDIO VDDIO pfet L=0.13U W=1U
Mt4tx_Mp_f29 t4tx/DP t4tx/GP VDDIO VDDIO pfet L=0.13U W=1U
Mt4tx_Mp_f30 t4tx/DP t4tx/GP VDDIO VDDIO pfet L=0.13U W=1U
Mt4tx_Mp_f31 t4tx/DP t4tx/GP VDDIO VDDIO pfet L=0.13U W=1U
Mt4tx_Mp_f32 t4tx/DP t4tx/GP VDDIO VDDIO pfet L=0.13U W=1U
Mt4tx_Mp_f33 t4tx/DP t4tx/GP VDDIO VDDIO pfet L=0.13U W=1U
Mt4tx_Mp_f34 t4tx/DP t4tx/GP VDDIO VDDIO pfet L=0.13U W=1U
Mt4tx_Mp_f35 t4tx/DP t4tx/GP VDDIO VDDIO pfet L=0.13U W=1U
Mt4tx_Mp_f36 t4tx/DP t4tx/GP VDDIO VDDIO pfet L=0.13U W=1U
Mt4tx_Mp_f37 t4tx/DP t4tx/GP VDDIO VDDIO pfet L=0.13U W=1U
Mt4tx_Mp_f38 t4tx/DP t4tx/GP VDDIO VDDIO pfet L=0.13U W=1U
Mt4tx_Mp_f39 t4tx/DP t4tx/GP VDDIO VDDIO pfet L=0.13U W=1U
Mt4tx_Mp_f40 t4tx/DP t4tx/GP VDDIO VDDIO pfet L=0.13U W=1U
Mt4tx_Mp_f41 t4tx/DP t4tx/GP VDDIO VDDIO pfet L=0.13U W=1U
Mt4tx_Mp_f42 t4tx/DP t4tx/GP VDDIO VDDIO pfet L=0.13U W=1U
Mt4tx_Mp_f43 t4tx/DP t4tx/GP VDDIO VDDIO pfet L=0.13U W=1U
Mt4tx_Mp_f44 t4tx/DP t4tx/GP VDDIO VDDIO pfet L=0.13U W=1U
Mt4tx_Mp_f45 t4tx/DP t4tx/GP VDDIO VDDIO pfet L=0.13U W=1U
Mt4tx_Mp_f46 t4tx/DP t4tx/GP VDDIO VDDIO pfet L=0.13U W=1U
Mt4tx_Mp_f47 t4tx/DP t4tx/GP VDDIO VDDIO pfet L=0.13U W=1U
Mt4tx_Mp_f48 t4tx/DP t4tx/GP VDDIO VDDIO pfet L=0.13U W=1U
Mt4tx_Mp_f49 t4tx/DP t4tx/GP VDDIO VDDIO pfet L=0.13U W=1U
Mt4tx_Mp_f50 t4tx/DP t4tx/GP VDDIO VDDIO pfet L=0.13U W=1U
Mt4tx_Mp_f51 t4tx/DP t4tx/GP VDDIO VDDIO pfet L=0.13U W=1U
Mt4tx_Mp_f52 t4tx/DP t4tx/GP VDDIO VDDIO pfet L=0.13U W=1U
Mt4tx_Mp_f53 t4tx/DP t4tx/GP VDDIO VDDIO pfet L=0.13U W=1U
Mt4tx_Mn_f0 t4tx/DN t4tx/GN VSS VSS nfet L=0.13U W=1U
Mt4tx_Mn_f1 t4tx/DN t4tx/GN VSS VSS nfet L=0.13U W=1U
Mt4tx_Mn_f2 t4tx/DN t4tx/GN VSS VSS nfet L=0.13U W=1U
Mt4tx_Mn_f3 t4tx/DN t4tx/GN VSS VSS nfet L=0.13U W=1U
Mt4tx_Mn_f4 t4tx/DN t4tx/GN VSS VSS nfet L=0.13U W=1U
Mt4tx_Mn_f5 t4tx/DN t4tx/GN VSS VSS nfet L=0.13U W=1U
Mt4tx_Mn_f6 t4tx/DN t4tx/GN VSS VSS nfet L=0.13U W=1U
Mt4tx_Mn_f7 t4tx/DN t4tx/GN VSS VSS nfet L=0.13U W=1U
Mt4tx_Mn_f8 t4tx/DN t4tx/GN VSS VSS nfet L=0.13U W=1U
Mt4tx_Mn_f9 t4tx/DN t4tx/GN VSS VSS nfet L=0.13U W=1U
Mt4tx_Mn_f10 t4tx/DN t4tx/GN VSS VSS nfet L=0.13U W=1U
Mt4tx_Mn_f11 t4tx/DN t4tx/GN VSS VSS nfet L=0.13U W=1U
Mt4tx_Mn_f12 t4tx/DN t4tx/GN VSS VSS nfet L=0.13U W=1U
Mt4tx_Mn_f13 t4tx/DN t4tx/GN VSS VSS nfet L=0.13U W=1U
Mt4tx_Mn_f14 t4tx/DN t4tx/GN VSS VSS nfet L=0.13U W=1U
Mt4tx_Mn_f15 t4tx/DN t4tx/GN VSS VSS nfet L=0.13U W=1U
Mt4tx_Mn_f16 t4tx/DN t4tx/GN VSS VSS nfet L=0.13U W=1U
Mt4tx_Mn_f17 t4tx/DN t4tx/GN VSS VSS nfet L=0.13U W=1U
Mt4tx_Mn_f18 t4tx/DN t4tx/GN VSS VSS nfet L=0.13U W=1U
Mt4tx_Mn_f19 t4tx/DN t4tx/GN VSS VSS nfet L=0.13U W=1U
Mt4tx_Mn_f20 t4tx/DN t4tx/GN VSS VSS nfet L=0.13U W=1U
Mt4tx_Mn_f21 t4tx/DN t4tx/GN VSS VSS nfet L=0.13U W=1U
Mt4tx_Mpu_f0 t4tx/PUX PUN VDDIO VDDIO pfet L=0.13U W=2U
Xt4tx_Rpu t4tx/PUX PAD$9 VSS rppd r=12472.0 L=24U W=0.5U
Mt4tx_Mpd_f0 t4tx/PDX PD VSS VSS nfet L=0.13U W=1U
Xt4tx_Rpd PAD$9 t4tx/PDX VSS rppd r=12472.0 L=24U W=0.5U
Xt4tx_Rsp t4tx/DP PAD$9 VSS rppd r=20.0 L=0.5U W=10U
Xt4tx_Rsn t4tx/DN PAD$9 VSS rppd r=20.0 L=0.5U W=10U
Dt5esd_Dp1 PAD$11 VDDIO diodevdd_mod A=35P P=58.08U
Dt5esd_Dp1_dsub VSS VDDIO dsub_2kv_mod A=224.956P P=81.12U
Mt5esd_Mn1_f0 PAD$11 VSS VSS VSS nfet L=0.13U W=2U
Mt5esd_Mn1_f1 PAD$11 VSS VSS VSS nfet L=0.13U W=2U
Mt5esd_Mn1_f2 PAD$11 VSS VSS VSS nfet L=0.13U W=2U
Mt5esd_Mn1_f3 PAD$11 VSS VSS VSS nfet L=0.13U W=2U
Mt5esd_Mn1_f4 PAD$11 VSS VSS VSS nfet L=0.13U W=2U
Mt5esd_Mn1_f5 PAD$11 VSS VSS VSS nfet L=0.13U W=2U
Mt5esd_Mn1_f6 PAD$11 VSS VSS VSS nfet L=0.13U W=2U
Mt5esd_Mn1_f7 PAD$11 VSS VSS VSS nfet L=0.13U W=2U
Mt5esd_Mn1_f8 PAD$11 VSS VSS VSS nfet L=0.13U W=2U
Mt5esd_Mn1_f9 PAD$11 VSS VSS VSS nfet L=0.13U W=2U
Mt5esd_Mclamp_f0 VDDIO VSS VSS VSS nfet L=0.35U W=2U
Mt5esd_Mclamp_f1 VDDIO VSS VSS VSS nfet L=0.35U W=2U
Mt5esd_Mclamp_f2 VDDIO VSS VSS VSS nfet L=0.35U W=2U
Mt5esd_Mclamp_f3 VDDIO VSS VSS VSS nfet L=0.35U W=2U
Mt5esd_Mclamp_f4 VDDIO VSS VSS VSS nfet L=0.35U W=2U
Mt5esd_Mclamp_f5 VDDIO VSS VSS VSS nfet L=0.35U W=2U
Mt5esd_Mclamp_f6 VDDIO VSS VSS VSS nfet L=0.35U W=2U
Mt5esd_Mclamp_f7 VDDIO VSS VSS VSS nfet L=0.35U W=2U
Mt5esd_Mclamp_f8 VDDIO VSS VSS VSS nfet L=0.35U W=2U
Mt5esd_Mclamp_f9 VDDIO VSS VSS VSS nfet L=0.35U W=2U
Mt5esd_Mclamp_f10 VDDIO VSS VSS VSS nfet L=0.35U W=2U
Mt5esd_Mclamp_f11 VDDIO VSS VSS VSS nfet L=0.35U W=2U
Mt5esd_Mclamp_f12 VDDIO VSS VSS VSS nfet L=0.35U W=2U
Mt5esd_Mclamp_f13 VDDIO VSS VSS VSS nfet L=0.35U W=2U
Mt5esd_Mclamp_f14 VDDIO VSS VSS VSS nfet L=0.35U W=2U
Mt5esd_Mclamp_f15 VDDIO VSS VSS VSS nfet L=0.35U W=2U
Mt5esd_Mclamp_f16 VDDIO VSS VSS VSS nfet L=0.35U W=2U
Mt5esd_Mclamp_f17 VDDIO VSS VSS VSS nfet L=0.35U W=2U
Mt5esd_Mclamp_f18 VDDIO VSS VSS VSS nfet L=0.35U W=2U
Mt5esd_Mclamp_f19 VDDIO VSS VSS VSS nfet L=0.35U W=2U
Xt5esd_Resd PAD$11 PADI_T5 VSS rppd r=164.6 L=1U W=2U
Dt5esd_Dp2 PADI_T5 VDDIO dpantenna A=4P P=8U
Mt5esd_Mn2_f0 PADI_T5 VSS VSS VSS nfet L=0.13U W=1U
Mt5tx_Mi1p_f0 t5tx/OEB OE VDDIO VDDIO pfet L=0.13U W=2U
Mt5tx_Mi1n_f0 t5tx/OEB OE VSS VSS nfet L=0.13U W=1U
Mt5tx_Mnd1p_f0 t5tx/GP DIN$5 VDDIO VDDIO pfet L=0.13U W=2U
Mt5tx_Mnd1p_f1 t5tx/GP DIN$5 VDDIO VDDIO pfet L=0.13U W=2U
Mt5tx_Mnd2p_f0 t5tx/GP OE VDDIO VDDIO pfet L=0.13U W=2U
Mt5tx_Mnd2p_f1 t5tx/GP OE VDDIO VDDIO pfet L=0.13U W=2U
Mt5tx_Mnd1n_f0 t5tx/GP DIN$5 t5tx/NA VSS nfet L=0.13U W=2U
Mt5tx_Mnd1n_f1 t5tx/GP DIN$5 t5tx/NA VSS nfet L=0.13U W=2U
Mt5tx_Mnd2n_f0 t5tx/NA OE VSS VSS nfet L=0.13U W=2U
Mt5tx_Mnd2n_f1 t5tx/NA OE VSS VSS nfet L=0.13U W=2U
Mt5tx_Mnr1p_f0 t5tx/NB DIN$5 VDDIO VDDIO pfet L=0.13U W=2U
Mt5tx_Mnr1p_f1 t5tx/NB DIN$5 VDDIO VDDIO pfet L=0.13U W=2U
Mt5tx_Mnr1p_f2 t5tx/NB DIN$5 VDDIO VDDIO pfet L=0.13U W=2U
Mt5tx_Mnr1p_f3 t5tx/NB DIN$5 VDDIO VDDIO pfet L=0.13U W=2U
Mt5tx_Mnr2p_f0 t5tx/GN t5tx/OEB t5tx/NB VDDIO pfet L=0.13U W=2U
Mt5tx_Mnr2p_f1 t5tx/GN t5tx/OEB t5tx/NB VDDIO pfet L=0.13U W=2U
Mt5tx_Mnr2p_f2 t5tx/GN t5tx/OEB t5tx/NB VDDIO pfet L=0.13U W=2U
Mt5tx_Mnr2p_f3 t5tx/GN t5tx/OEB t5tx/NB VDDIO pfet L=0.13U W=2U
Mt5tx_Mnr1n_f0 t5tx/GN DIN$5 VSS VSS nfet L=0.13U W=1U
Mt5tx_Mnr1n_f1 t5tx/GN DIN$5 VSS VSS nfet L=0.13U W=1U
Mt5tx_Mnr2n_f0 t5tx/GN t5tx/OEB VSS VSS nfet L=0.13U W=1U
Mt5tx_Mnr2n_f1 t5tx/GN t5tx/OEB VSS VSS nfet L=0.13U W=1U
Mt5tx_Mp_f0 t5tx/DP t5tx/GP VDDIO VDDIO pfet L=0.13U W=1U
Mt5tx_Mp_f1 t5tx/DP t5tx/GP VDDIO VDDIO pfet L=0.13U W=1U
Mt5tx_Mp_f2 t5tx/DP t5tx/GP VDDIO VDDIO pfet L=0.13U W=1U
Mt5tx_Mp_f3 t5tx/DP t5tx/GP VDDIO VDDIO pfet L=0.13U W=1U
Mt5tx_Mp_f4 t5tx/DP t5tx/GP VDDIO VDDIO pfet L=0.13U W=1U
Mt5tx_Mp_f5 t5tx/DP t5tx/GP VDDIO VDDIO pfet L=0.13U W=1U
Mt5tx_Mp_f6 t5tx/DP t5tx/GP VDDIO VDDIO pfet L=0.13U W=1U
Mt5tx_Mp_f7 t5tx/DP t5tx/GP VDDIO VDDIO pfet L=0.13U W=1U
Mt5tx_Mp_f8 t5tx/DP t5tx/GP VDDIO VDDIO pfet L=0.13U W=1U
Mt5tx_Mp_f9 t5tx/DP t5tx/GP VDDIO VDDIO pfet L=0.13U W=1U
Mt5tx_Mp_f10 t5tx/DP t5tx/GP VDDIO VDDIO pfet L=0.13U W=1U
Mt5tx_Mp_f11 t5tx/DP t5tx/GP VDDIO VDDIO pfet L=0.13U W=1U
Mt5tx_Mp_f12 t5tx/DP t5tx/GP VDDIO VDDIO pfet L=0.13U W=1U
Mt5tx_Mp_f13 t5tx/DP t5tx/GP VDDIO VDDIO pfet L=0.13U W=1U
Mt5tx_Mp_f14 t5tx/DP t5tx/GP VDDIO VDDIO pfet L=0.13U W=1U
Mt5tx_Mp_f15 t5tx/DP t5tx/GP VDDIO VDDIO pfet L=0.13U W=1U
Mt5tx_Mp_f16 t5tx/DP t5tx/GP VDDIO VDDIO pfet L=0.13U W=1U
Mt5tx_Mp_f17 t5tx/DP t5tx/GP VDDIO VDDIO pfet L=0.13U W=1U
Mt5tx_Mp_f18 t5tx/DP t5tx/GP VDDIO VDDIO pfet L=0.13U W=1U
Mt5tx_Mp_f19 t5tx/DP t5tx/GP VDDIO VDDIO pfet L=0.13U W=1U
Mt5tx_Mp_f20 t5tx/DP t5tx/GP VDDIO VDDIO pfet L=0.13U W=1U
Mt5tx_Mp_f21 t5tx/DP t5tx/GP VDDIO VDDIO pfet L=0.13U W=1U
Mt5tx_Mp_f22 t5tx/DP t5tx/GP VDDIO VDDIO pfet L=0.13U W=1U
Mt5tx_Mp_f23 t5tx/DP t5tx/GP VDDIO VDDIO pfet L=0.13U W=1U
Mt5tx_Mp_f24 t5tx/DP t5tx/GP VDDIO VDDIO pfet L=0.13U W=1U
Mt5tx_Mp_f25 t5tx/DP t5tx/GP VDDIO VDDIO pfet L=0.13U W=1U
Mt5tx_Mp_f26 t5tx/DP t5tx/GP VDDIO VDDIO pfet L=0.13U W=1U
Mt5tx_Mp_f27 t5tx/DP t5tx/GP VDDIO VDDIO pfet L=0.13U W=1U
Mt5tx_Mp_f28 t5tx/DP t5tx/GP VDDIO VDDIO pfet L=0.13U W=1U
Mt5tx_Mp_f29 t5tx/DP t5tx/GP VDDIO VDDIO pfet L=0.13U W=1U
Mt5tx_Mp_f30 t5tx/DP t5tx/GP VDDIO VDDIO pfet L=0.13U W=1U
Mt5tx_Mp_f31 t5tx/DP t5tx/GP VDDIO VDDIO pfet L=0.13U W=1U
Mt5tx_Mp_f32 t5tx/DP t5tx/GP VDDIO VDDIO pfet L=0.13U W=1U
Mt5tx_Mp_f33 t5tx/DP t5tx/GP VDDIO VDDIO pfet L=0.13U W=1U
Mt5tx_Mp_f34 t5tx/DP t5tx/GP VDDIO VDDIO pfet L=0.13U W=1U
Mt5tx_Mp_f35 t5tx/DP t5tx/GP VDDIO VDDIO pfet L=0.13U W=1U
Mt5tx_Mp_f36 t5tx/DP t5tx/GP VDDIO VDDIO pfet L=0.13U W=1U
Mt5tx_Mp_f37 t5tx/DP t5tx/GP VDDIO VDDIO pfet L=0.13U W=1U
Mt5tx_Mp_f38 t5tx/DP t5tx/GP VDDIO VDDIO pfet L=0.13U W=1U
Mt5tx_Mp_f39 t5tx/DP t5tx/GP VDDIO VDDIO pfet L=0.13U W=1U
Mt5tx_Mp_f40 t5tx/DP t5tx/GP VDDIO VDDIO pfet L=0.13U W=1U
Mt5tx_Mp_f41 t5tx/DP t5tx/GP VDDIO VDDIO pfet L=0.13U W=1U
Mt5tx_Mp_f42 t5tx/DP t5tx/GP VDDIO VDDIO pfet L=0.13U W=1U
Mt5tx_Mp_f43 t5tx/DP t5tx/GP VDDIO VDDIO pfet L=0.13U W=1U
Mt5tx_Mp_f44 t5tx/DP t5tx/GP VDDIO VDDIO pfet L=0.13U W=1U
Mt5tx_Mp_f45 t5tx/DP t5tx/GP VDDIO VDDIO pfet L=0.13U W=1U
Mt5tx_Mp_f46 t5tx/DP t5tx/GP VDDIO VDDIO pfet L=0.13U W=1U
Mt5tx_Mp_f47 t5tx/DP t5tx/GP VDDIO VDDIO pfet L=0.13U W=1U
Mt5tx_Mp_f48 t5tx/DP t5tx/GP VDDIO VDDIO pfet L=0.13U W=1U
Mt5tx_Mp_f49 t5tx/DP t5tx/GP VDDIO VDDIO pfet L=0.13U W=1U
Mt5tx_Mp_f50 t5tx/DP t5tx/GP VDDIO VDDIO pfet L=0.13U W=1U
Mt5tx_Mp_f51 t5tx/DP t5tx/GP VDDIO VDDIO pfet L=0.13U W=1U
Mt5tx_Mp_f52 t5tx/DP t5tx/GP VDDIO VDDIO pfet L=0.13U W=1U
Mt5tx_Mp_f53 t5tx/DP t5tx/GP VDDIO VDDIO pfet L=0.13U W=1U
Mt5tx_Mn_f0 t5tx/DN t5tx/GN VSS VSS nfet L=0.13U W=1U
Mt5tx_Mn_f1 t5tx/DN t5tx/GN VSS VSS nfet L=0.13U W=1U
Mt5tx_Mn_f2 t5tx/DN t5tx/GN VSS VSS nfet L=0.13U W=1U
Mt5tx_Mn_f3 t5tx/DN t5tx/GN VSS VSS nfet L=0.13U W=1U
Mt5tx_Mn_f4 t5tx/DN t5tx/GN VSS VSS nfet L=0.13U W=1U
Mt5tx_Mn_f5 t5tx/DN t5tx/GN VSS VSS nfet L=0.13U W=1U
Mt5tx_Mn_f6 t5tx/DN t5tx/GN VSS VSS nfet L=0.13U W=1U
Mt5tx_Mn_f7 t5tx/DN t5tx/GN VSS VSS nfet L=0.13U W=1U
Mt5tx_Mn_f8 t5tx/DN t5tx/GN VSS VSS nfet L=0.13U W=1U
Mt5tx_Mn_f9 t5tx/DN t5tx/GN VSS VSS nfet L=0.13U W=1U
Mt5tx_Mn_f10 t5tx/DN t5tx/GN VSS VSS nfet L=0.13U W=1U
Mt5tx_Mn_f11 t5tx/DN t5tx/GN VSS VSS nfet L=0.13U W=1U
Mt5tx_Mn_f12 t5tx/DN t5tx/GN VSS VSS nfet L=0.13U W=1U
Mt5tx_Mn_f13 t5tx/DN t5tx/GN VSS VSS nfet L=0.13U W=1U
Mt5tx_Mn_f14 t5tx/DN t5tx/GN VSS VSS nfet L=0.13U W=1U
Mt5tx_Mn_f15 t5tx/DN t5tx/GN VSS VSS nfet L=0.13U W=1U
Mt5tx_Mn_f16 t5tx/DN t5tx/GN VSS VSS nfet L=0.13U W=1U
Mt5tx_Mn_f17 t5tx/DN t5tx/GN VSS VSS nfet L=0.13U W=1U
Mt5tx_Mn_f18 t5tx/DN t5tx/GN VSS VSS nfet L=0.13U W=1U
Mt5tx_Mn_f19 t5tx/DN t5tx/GN VSS VSS nfet L=0.13U W=1U
Mt5tx_Mn_f20 t5tx/DN t5tx/GN VSS VSS nfet L=0.13U W=1U
Mt5tx_Mn_f21 t5tx/DN t5tx/GN VSS VSS nfet L=0.13U W=1U
Mt5tx_Mpu_f0 t5tx/PUX PUN VDDIO VDDIO pfet L=0.13U W=2U
Xt5tx_Rpu t5tx/PUX PAD$11 VSS rppd r=12472.0 L=24U W=0.5U
Mt5tx_Mpd_f0 t5tx/PDX PD VSS VSS nfet L=0.13U W=1U
Xt5tx_Rpd PAD$11 t5tx/PDX VSS rppd r=12472.0 L=24U W=0.5U
Xt5tx_Rsp t5tx/DP PAD$11 VSS rppd r=20.0 L=0.5U W=10U
Xt5tx_Rsn t5tx/DN PAD$11 VSS rppd r=20.0 L=0.5U W=10U
Dt6esd_Dp1 PAD$13 VDDIO diodevdd_mod A=35P P=58.08U
Dt6esd_Dp1_dsub VSS VDDIO dsub_2kv_mod A=224.956P P=81.12U
Mt6esd_Mn1_f0 PAD$13 VSS VSS VSS nfet L=0.13U W=2U
Mt6esd_Mn1_f1 PAD$13 VSS VSS VSS nfet L=0.13U W=2U
Mt6esd_Mn1_f2 PAD$13 VSS VSS VSS nfet L=0.13U W=2U
Mt6esd_Mn1_f3 PAD$13 VSS VSS VSS nfet L=0.13U W=2U
Mt6esd_Mn1_f4 PAD$13 VSS VSS VSS nfet L=0.13U W=2U
Mt6esd_Mn1_f5 PAD$13 VSS VSS VSS nfet L=0.13U W=2U
Mt6esd_Mn1_f6 PAD$13 VSS VSS VSS nfet L=0.13U W=2U
Mt6esd_Mn1_f7 PAD$13 VSS VSS VSS nfet L=0.13U W=2U
Mt6esd_Mn1_f8 PAD$13 VSS VSS VSS nfet L=0.13U W=2U
Mt6esd_Mn1_f9 PAD$13 VSS VSS VSS nfet L=0.13U W=2U
Mt6esd_Mclamp_f0 VDDIO VSS VSS VSS nfet L=0.35U W=2U
Mt6esd_Mclamp_f1 VDDIO VSS VSS VSS nfet L=0.35U W=2U
Mt6esd_Mclamp_f2 VDDIO VSS VSS VSS nfet L=0.35U W=2U
Mt6esd_Mclamp_f3 VDDIO VSS VSS VSS nfet L=0.35U W=2U
Mt6esd_Mclamp_f4 VDDIO VSS VSS VSS nfet L=0.35U W=2U
Mt6esd_Mclamp_f5 VDDIO VSS VSS VSS nfet L=0.35U W=2U
Mt6esd_Mclamp_f6 VDDIO VSS VSS VSS nfet L=0.35U W=2U
Mt6esd_Mclamp_f7 VDDIO VSS VSS VSS nfet L=0.35U W=2U
Mt6esd_Mclamp_f8 VDDIO VSS VSS VSS nfet L=0.35U W=2U
Mt6esd_Mclamp_f9 VDDIO VSS VSS VSS nfet L=0.35U W=2U
Mt6esd_Mclamp_f10 VDDIO VSS VSS VSS nfet L=0.35U W=2U
Mt6esd_Mclamp_f11 VDDIO VSS VSS VSS nfet L=0.35U W=2U
Mt6esd_Mclamp_f12 VDDIO VSS VSS VSS nfet L=0.35U W=2U
Mt6esd_Mclamp_f13 VDDIO VSS VSS VSS nfet L=0.35U W=2U
Mt6esd_Mclamp_f14 VDDIO VSS VSS VSS nfet L=0.35U W=2U
Mt6esd_Mclamp_f15 VDDIO VSS VSS VSS nfet L=0.35U W=2U
Mt6esd_Mclamp_f16 VDDIO VSS VSS VSS nfet L=0.35U W=2U
Mt6esd_Mclamp_f17 VDDIO VSS VSS VSS nfet L=0.35U W=2U
Mt6esd_Mclamp_f18 VDDIO VSS VSS VSS nfet L=0.35U W=2U
Mt6esd_Mclamp_f19 VDDIO VSS VSS VSS nfet L=0.35U W=2U
Xt6esd_Resd PAD$13 PADI_T6 VSS rppd r=164.6 L=1U W=2U
Dt6esd_Dp2 PADI_T6 VDDIO dpantenna A=4P P=8U
Mt6esd_Mn2_f0 PADI_T6 VSS VSS VSS nfet L=0.13U W=1U
Mt6tx_Mi1p_f0 t6tx/OEB OE VDDIO VDDIO pfet L=0.13U W=2U
Mt6tx_Mi1n_f0 t6tx/OEB OE VSS VSS nfet L=0.13U W=1U
Mt6tx_Mnd1p_f0 t6tx/GP DIN$6 VDDIO VDDIO pfet L=0.13U W=2U
Mt6tx_Mnd1p_f1 t6tx/GP DIN$6 VDDIO VDDIO pfet L=0.13U W=2U
Mt6tx_Mnd2p_f0 t6tx/GP OE VDDIO VDDIO pfet L=0.13U W=2U
Mt6tx_Mnd2p_f1 t6tx/GP OE VDDIO VDDIO pfet L=0.13U W=2U
Mt6tx_Mnd1n_f0 t6tx/GP DIN$6 t6tx/NA VSS nfet L=0.13U W=2U
Mt6tx_Mnd1n_f1 t6tx/GP DIN$6 t6tx/NA VSS nfet L=0.13U W=2U
Mt6tx_Mnd2n_f0 t6tx/NA OE VSS VSS nfet L=0.13U W=2U
Mt6tx_Mnd2n_f1 t6tx/NA OE VSS VSS nfet L=0.13U W=2U
Mt6tx_Mnr1p_f0 t6tx/NB DIN$6 VDDIO VDDIO pfet L=0.13U W=2U
Mt6tx_Mnr1p_f1 t6tx/NB DIN$6 VDDIO VDDIO pfet L=0.13U W=2U
Mt6tx_Mnr1p_f2 t6tx/NB DIN$6 VDDIO VDDIO pfet L=0.13U W=2U
Mt6tx_Mnr1p_f3 t6tx/NB DIN$6 VDDIO VDDIO pfet L=0.13U W=2U
Mt6tx_Mnr2p_f0 t6tx/GN t6tx/OEB t6tx/NB VDDIO pfet L=0.13U W=2U
Mt6tx_Mnr2p_f1 t6tx/GN t6tx/OEB t6tx/NB VDDIO pfet L=0.13U W=2U
Mt6tx_Mnr2p_f2 t6tx/GN t6tx/OEB t6tx/NB VDDIO pfet L=0.13U W=2U
Mt6tx_Mnr2p_f3 t6tx/GN t6tx/OEB t6tx/NB VDDIO pfet L=0.13U W=2U
Mt6tx_Mnr1n_f0 t6tx/GN DIN$6 VSS VSS nfet L=0.13U W=1U
Mt6tx_Mnr1n_f1 t6tx/GN DIN$6 VSS VSS nfet L=0.13U W=1U
Mt6tx_Mnr2n_f0 t6tx/GN t6tx/OEB VSS VSS nfet L=0.13U W=1U
Mt6tx_Mnr2n_f1 t6tx/GN t6tx/OEB VSS VSS nfet L=0.13U W=1U
Mt6tx_Mp_f0 t6tx/DP t6tx/GP VDDIO VDDIO pfet L=0.13U W=1U
Mt6tx_Mp_f1 t6tx/DP t6tx/GP VDDIO VDDIO pfet L=0.13U W=1U
Mt6tx_Mp_f2 t6tx/DP t6tx/GP VDDIO VDDIO pfet L=0.13U W=1U
Mt6tx_Mp_f3 t6tx/DP t6tx/GP VDDIO VDDIO pfet L=0.13U W=1U
Mt6tx_Mp_f4 t6tx/DP t6tx/GP VDDIO VDDIO pfet L=0.13U W=1U
Mt6tx_Mp_f5 t6tx/DP t6tx/GP VDDIO VDDIO pfet L=0.13U W=1U
Mt6tx_Mp_f6 t6tx/DP t6tx/GP VDDIO VDDIO pfet L=0.13U W=1U
Mt6tx_Mp_f7 t6tx/DP t6tx/GP VDDIO VDDIO pfet L=0.13U W=1U
Mt6tx_Mp_f8 t6tx/DP t6tx/GP VDDIO VDDIO pfet L=0.13U W=1U
Mt6tx_Mp_f9 t6tx/DP t6tx/GP VDDIO VDDIO pfet L=0.13U W=1U
Mt6tx_Mp_f10 t6tx/DP t6tx/GP VDDIO VDDIO pfet L=0.13U W=1U
Mt6tx_Mp_f11 t6tx/DP t6tx/GP VDDIO VDDIO pfet L=0.13U W=1U
Mt6tx_Mp_f12 t6tx/DP t6tx/GP VDDIO VDDIO pfet L=0.13U W=1U
Mt6tx_Mp_f13 t6tx/DP t6tx/GP VDDIO VDDIO pfet L=0.13U W=1U
Mt6tx_Mp_f14 t6tx/DP t6tx/GP VDDIO VDDIO pfet L=0.13U W=1U
Mt6tx_Mp_f15 t6tx/DP t6tx/GP VDDIO VDDIO pfet L=0.13U W=1U
Mt6tx_Mp_f16 t6tx/DP t6tx/GP VDDIO VDDIO pfet L=0.13U W=1U
Mt6tx_Mp_f17 t6tx/DP t6tx/GP VDDIO VDDIO pfet L=0.13U W=1U
Mt6tx_Mp_f18 t6tx/DP t6tx/GP VDDIO VDDIO pfet L=0.13U W=1U
Mt6tx_Mp_f19 t6tx/DP t6tx/GP VDDIO VDDIO pfet L=0.13U W=1U
Mt6tx_Mp_f20 t6tx/DP t6tx/GP VDDIO VDDIO pfet L=0.13U W=1U
Mt6tx_Mp_f21 t6tx/DP t6tx/GP VDDIO VDDIO pfet L=0.13U W=1U
Mt6tx_Mp_f22 t6tx/DP t6tx/GP VDDIO VDDIO pfet L=0.13U W=1U
Mt6tx_Mp_f23 t6tx/DP t6tx/GP VDDIO VDDIO pfet L=0.13U W=1U
Mt6tx_Mp_f24 t6tx/DP t6tx/GP VDDIO VDDIO pfet L=0.13U W=1U
Mt6tx_Mp_f25 t6tx/DP t6tx/GP VDDIO VDDIO pfet L=0.13U W=1U
Mt6tx_Mp_f26 t6tx/DP t6tx/GP VDDIO VDDIO pfet L=0.13U W=1U
Mt6tx_Mp_f27 t6tx/DP t6tx/GP VDDIO VDDIO pfet L=0.13U W=1U
Mt6tx_Mp_f28 t6tx/DP t6tx/GP VDDIO VDDIO pfet L=0.13U W=1U
Mt6tx_Mp_f29 t6tx/DP t6tx/GP VDDIO VDDIO pfet L=0.13U W=1U
Mt6tx_Mp_f30 t6tx/DP t6tx/GP VDDIO VDDIO pfet L=0.13U W=1U
Mt6tx_Mp_f31 t6tx/DP t6tx/GP VDDIO VDDIO pfet L=0.13U W=1U
Mt6tx_Mp_f32 t6tx/DP t6tx/GP VDDIO VDDIO pfet L=0.13U W=1U
Mt6tx_Mp_f33 t6tx/DP t6tx/GP VDDIO VDDIO pfet L=0.13U W=1U
Mt6tx_Mp_f34 t6tx/DP t6tx/GP VDDIO VDDIO pfet L=0.13U W=1U
Mt6tx_Mp_f35 t6tx/DP t6tx/GP VDDIO VDDIO pfet L=0.13U W=1U
Mt6tx_Mp_f36 t6tx/DP t6tx/GP VDDIO VDDIO pfet L=0.13U W=1U
Mt6tx_Mp_f37 t6tx/DP t6tx/GP VDDIO VDDIO pfet L=0.13U W=1U
Mt6tx_Mp_f38 t6tx/DP t6tx/GP VDDIO VDDIO pfet L=0.13U W=1U
Mt6tx_Mp_f39 t6tx/DP t6tx/GP VDDIO VDDIO pfet L=0.13U W=1U
Mt6tx_Mp_f40 t6tx/DP t6tx/GP VDDIO VDDIO pfet L=0.13U W=1U
Mt6tx_Mp_f41 t6tx/DP t6tx/GP VDDIO VDDIO pfet L=0.13U W=1U
Mt6tx_Mp_f42 t6tx/DP t6tx/GP VDDIO VDDIO pfet L=0.13U W=1U
Mt6tx_Mp_f43 t6tx/DP t6tx/GP VDDIO VDDIO pfet L=0.13U W=1U
Mt6tx_Mp_f44 t6tx/DP t6tx/GP VDDIO VDDIO pfet L=0.13U W=1U
Mt6tx_Mp_f45 t6tx/DP t6tx/GP VDDIO VDDIO pfet L=0.13U W=1U
Mt6tx_Mp_f46 t6tx/DP t6tx/GP VDDIO VDDIO pfet L=0.13U W=1U
Mt6tx_Mp_f47 t6tx/DP t6tx/GP VDDIO VDDIO pfet L=0.13U W=1U
Mt6tx_Mp_f48 t6tx/DP t6tx/GP VDDIO VDDIO pfet L=0.13U W=1U
Mt6tx_Mp_f49 t6tx/DP t6tx/GP VDDIO VDDIO pfet L=0.13U W=1U
Mt6tx_Mp_f50 t6tx/DP t6tx/GP VDDIO VDDIO pfet L=0.13U W=1U
Mt6tx_Mp_f51 t6tx/DP t6tx/GP VDDIO VDDIO pfet L=0.13U W=1U
Mt6tx_Mp_f52 t6tx/DP t6tx/GP VDDIO VDDIO pfet L=0.13U W=1U
Mt6tx_Mp_f53 t6tx/DP t6tx/GP VDDIO VDDIO pfet L=0.13U W=1U
Mt6tx_Mn_f0 t6tx/DN t6tx/GN VSS VSS nfet L=0.13U W=1U
Mt6tx_Mn_f1 t6tx/DN t6tx/GN VSS VSS nfet L=0.13U W=1U
Mt6tx_Mn_f2 t6tx/DN t6tx/GN VSS VSS nfet L=0.13U W=1U
Mt6tx_Mn_f3 t6tx/DN t6tx/GN VSS VSS nfet L=0.13U W=1U
Mt6tx_Mn_f4 t6tx/DN t6tx/GN VSS VSS nfet L=0.13U W=1U
Mt6tx_Mn_f5 t6tx/DN t6tx/GN VSS VSS nfet L=0.13U W=1U
Mt6tx_Mn_f6 t6tx/DN t6tx/GN VSS VSS nfet L=0.13U W=1U
Mt6tx_Mn_f7 t6tx/DN t6tx/GN VSS VSS nfet L=0.13U W=1U
Mt6tx_Mn_f8 t6tx/DN t6tx/GN VSS VSS nfet L=0.13U W=1U
Mt6tx_Mn_f9 t6tx/DN t6tx/GN VSS VSS nfet L=0.13U W=1U
Mt6tx_Mn_f10 t6tx/DN t6tx/GN VSS VSS nfet L=0.13U W=1U
Mt6tx_Mn_f11 t6tx/DN t6tx/GN VSS VSS nfet L=0.13U W=1U
Mt6tx_Mn_f12 t6tx/DN t6tx/GN VSS VSS nfet L=0.13U W=1U
Mt6tx_Mn_f13 t6tx/DN t6tx/GN VSS VSS nfet L=0.13U W=1U
Mt6tx_Mn_f14 t6tx/DN t6tx/GN VSS VSS nfet L=0.13U W=1U
Mt6tx_Mn_f15 t6tx/DN t6tx/GN VSS VSS nfet L=0.13U W=1U
Mt6tx_Mn_f16 t6tx/DN t6tx/GN VSS VSS nfet L=0.13U W=1U
Mt6tx_Mn_f17 t6tx/DN t6tx/GN VSS VSS nfet L=0.13U W=1U
Mt6tx_Mn_f18 t6tx/DN t6tx/GN VSS VSS nfet L=0.13U W=1U
Mt6tx_Mn_f19 t6tx/DN t6tx/GN VSS VSS nfet L=0.13U W=1U
Mt6tx_Mn_f20 t6tx/DN t6tx/GN VSS VSS nfet L=0.13U W=1U
Mt6tx_Mn_f21 t6tx/DN t6tx/GN VSS VSS nfet L=0.13U W=1U
Mt6tx_Mpu_f0 t6tx/PUX PUN VDDIO VDDIO pfet L=0.13U W=2U
Xt6tx_Rpu t6tx/PUX PAD$13 VSS rppd r=12472.0 L=24U W=0.5U
Mt6tx_Mpd_f0 t6tx/PDX PD VSS VSS nfet L=0.13U W=1U
Xt6tx_Rpd PAD$13 t6tx/PDX VSS rppd r=12472.0 L=24U W=0.5U
Xt6tx_Rsp t6tx/DP PAD$13 VSS rppd r=20.0 L=0.5U W=10U
Xt6tx_Rsn t6tx/DN PAD$13 VSS rppd r=20.0 L=0.5U W=10U
Dt7esd_Dp1 PAD$15 VDDIO diodevdd_mod A=35P P=58.08U
Dt7esd_Dp1_dsub VSS VDDIO dsub_2kv_mod A=224.956P P=81.12U
Mt7esd_Mn1_f0 PAD$15 VSS VSS VSS nfet L=0.13U W=2U
Mt7esd_Mn1_f1 PAD$15 VSS VSS VSS nfet L=0.13U W=2U
Mt7esd_Mn1_f2 PAD$15 VSS VSS VSS nfet L=0.13U W=2U
Mt7esd_Mn1_f3 PAD$15 VSS VSS VSS nfet L=0.13U W=2U
Mt7esd_Mn1_f4 PAD$15 VSS VSS VSS nfet L=0.13U W=2U
Mt7esd_Mn1_f5 PAD$15 VSS VSS VSS nfet L=0.13U W=2U
Mt7esd_Mn1_f6 PAD$15 VSS VSS VSS nfet L=0.13U W=2U
Mt7esd_Mn1_f7 PAD$15 VSS VSS VSS nfet L=0.13U W=2U
Mt7esd_Mn1_f8 PAD$15 VSS VSS VSS nfet L=0.13U W=2U
Mt7esd_Mn1_f9 PAD$15 VSS VSS VSS nfet L=0.13U W=2U
Mt7esd_Mclamp_f0 VDDIO VSS VSS VSS nfet L=0.35U W=2U
Mt7esd_Mclamp_f1 VDDIO VSS VSS VSS nfet L=0.35U W=2U
Mt7esd_Mclamp_f2 VDDIO VSS VSS VSS nfet L=0.35U W=2U
Mt7esd_Mclamp_f3 VDDIO VSS VSS VSS nfet L=0.35U W=2U
Mt7esd_Mclamp_f4 VDDIO VSS VSS VSS nfet L=0.35U W=2U
Mt7esd_Mclamp_f5 VDDIO VSS VSS VSS nfet L=0.35U W=2U
Mt7esd_Mclamp_f6 VDDIO VSS VSS VSS nfet L=0.35U W=2U
Mt7esd_Mclamp_f7 VDDIO VSS VSS VSS nfet L=0.35U W=2U
Mt7esd_Mclamp_f8 VDDIO VSS VSS VSS nfet L=0.35U W=2U
Mt7esd_Mclamp_f9 VDDIO VSS VSS VSS nfet L=0.35U W=2U
Mt7esd_Mclamp_f10 VDDIO VSS VSS VSS nfet L=0.35U W=2U
Mt7esd_Mclamp_f11 VDDIO VSS VSS VSS nfet L=0.35U W=2U
Mt7esd_Mclamp_f12 VDDIO VSS VSS VSS nfet L=0.35U W=2U
Mt7esd_Mclamp_f13 VDDIO VSS VSS VSS nfet L=0.35U W=2U
Mt7esd_Mclamp_f14 VDDIO VSS VSS VSS nfet L=0.35U W=2U
Mt7esd_Mclamp_f15 VDDIO VSS VSS VSS nfet L=0.35U W=2U
Mt7esd_Mclamp_f16 VDDIO VSS VSS VSS nfet L=0.35U W=2U
Mt7esd_Mclamp_f17 VDDIO VSS VSS VSS nfet L=0.35U W=2U
Mt7esd_Mclamp_f18 VDDIO VSS VSS VSS nfet L=0.35U W=2U
Mt7esd_Mclamp_f19 VDDIO VSS VSS VSS nfet L=0.35U W=2U
Xt7esd_Resd PAD$15 PADI_T7 VSS rppd r=164.6 L=1U W=2U
Dt7esd_Dp2 PADI_T7 VDDIO dpantenna A=4P P=8U
Mt7esd_Mn2_f0 PADI_T7 VSS VSS VSS nfet L=0.13U W=1U
Mt7tx_Mi1p_f0 t7tx/OEB OE VDDIO VDDIO pfet L=0.13U W=2U
Mt7tx_Mi1n_f0 t7tx/OEB OE VSS VSS nfet L=0.13U W=1U
Mt7tx_Mnd1p_f0 t7tx/GP DIN$7 VDDIO VDDIO pfet L=0.13U W=2U
Mt7tx_Mnd1p_f1 t7tx/GP DIN$7 VDDIO VDDIO pfet L=0.13U W=2U
Mt7tx_Mnd2p_f0 t7tx/GP OE VDDIO VDDIO pfet L=0.13U W=2U
Mt7tx_Mnd2p_f1 t7tx/GP OE VDDIO VDDIO pfet L=0.13U W=2U
Mt7tx_Mnd1n_f0 t7tx/GP DIN$7 t7tx/NA VSS nfet L=0.13U W=2U
Mt7tx_Mnd1n_f1 t7tx/GP DIN$7 t7tx/NA VSS nfet L=0.13U W=2U
Mt7tx_Mnd2n_f0 t7tx/NA OE VSS VSS nfet L=0.13U W=2U
Mt7tx_Mnd2n_f1 t7tx/NA OE VSS VSS nfet L=0.13U W=2U
Mt7tx_Mnr1p_f0 t7tx/NB DIN$7 VDDIO VDDIO pfet L=0.13U W=2U
Mt7tx_Mnr1p_f1 t7tx/NB DIN$7 VDDIO VDDIO pfet L=0.13U W=2U
Mt7tx_Mnr1p_f2 t7tx/NB DIN$7 VDDIO VDDIO pfet L=0.13U W=2U
Mt7tx_Mnr1p_f3 t7tx/NB DIN$7 VDDIO VDDIO pfet L=0.13U W=2U
Mt7tx_Mnr2p_f0 t7tx/GN t7tx/OEB t7tx/NB VDDIO pfet L=0.13U W=2U
Mt7tx_Mnr2p_f1 t7tx/GN t7tx/OEB t7tx/NB VDDIO pfet L=0.13U W=2U
Mt7tx_Mnr2p_f2 t7tx/GN t7tx/OEB t7tx/NB VDDIO pfet L=0.13U W=2U
Mt7tx_Mnr2p_f3 t7tx/GN t7tx/OEB t7tx/NB VDDIO pfet L=0.13U W=2U
Mt7tx_Mnr1n_f0 t7tx/GN DIN$7 VSS VSS nfet L=0.13U W=1U
Mt7tx_Mnr1n_f1 t7tx/GN DIN$7 VSS VSS nfet L=0.13U W=1U
Mt7tx_Mnr2n_f0 t7tx/GN t7tx/OEB VSS VSS nfet L=0.13U W=1U
Mt7tx_Mnr2n_f1 t7tx/GN t7tx/OEB VSS VSS nfet L=0.13U W=1U
Mt7tx_Mp_f0 t7tx/DP t7tx/GP VDDIO VDDIO pfet L=0.13U W=1U
Mt7tx_Mp_f1 t7tx/DP t7tx/GP VDDIO VDDIO pfet L=0.13U W=1U
Mt7tx_Mp_f2 t7tx/DP t7tx/GP VDDIO VDDIO pfet L=0.13U W=1U
Mt7tx_Mp_f3 t7tx/DP t7tx/GP VDDIO VDDIO pfet L=0.13U W=1U
Mt7tx_Mp_f4 t7tx/DP t7tx/GP VDDIO VDDIO pfet L=0.13U W=1U
Mt7tx_Mp_f5 t7tx/DP t7tx/GP VDDIO VDDIO pfet L=0.13U W=1U
Mt7tx_Mp_f6 t7tx/DP t7tx/GP VDDIO VDDIO pfet L=0.13U W=1U
Mt7tx_Mp_f7 t7tx/DP t7tx/GP VDDIO VDDIO pfet L=0.13U W=1U
Mt7tx_Mp_f8 t7tx/DP t7tx/GP VDDIO VDDIO pfet L=0.13U W=1U
Mt7tx_Mp_f9 t7tx/DP t7tx/GP VDDIO VDDIO pfet L=0.13U W=1U
Mt7tx_Mp_f10 t7tx/DP t7tx/GP VDDIO VDDIO pfet L=0.13U W=1U
Mt7tx_Mp_f11 t7tx/DP t7tx/GP VDDIO VDDIO pfet L=0.13U W=1U
Mt7tx_Mp_f12 t7tx/DP t7tx/GP VDDIO VDDIO pfet L=0.13U W=1U
Mt7tx_Mp_f13 t7tx/DP t7tx/GP VDDIO VDDIO pfet L=0.13U W=1U
Mt7tx_Mp_f14 t7tx/DP t7tx/GP VDDIO VDDIO pfet L=0.13U W=1U
Mt7tx_Mp_f15 t7tx/DP t7tx/GP VDDIO VDDIO pfet L=0.13U W=1U
Mt7tx_Mp_f16 t7tx/DP t7tx/GP VDDIO VDDIO pfet L=0.13U W=1U
Mt7tx_Mp_f17 t7tx/DP t7tx/GP VDDIO VDDIO pfet L=0.13U W=1U
Mt7tx_Mp_f18 t7tx/DP t7tx/GP VDDIO VDDIO pfet L=0.13U W=1U
Mt7tx_Mp_f19 t7tx/DP t7tx/GP VDDIO VDDIO pfet L=0.13U W=1U
Mt7tx_Mp_f20 t7tx/DP t7tx/GP VDDIO VDDIO pfet L=0.13U W=1U
Mt7tx_Mp_f21 t7tx/DP t7tx/GP VDDIO VDDIO pfet L=0.13U W=1U
Mt7tx_Mp_f22 t7tx/DP t7tx/GP VDDIO VDDIO pfet L=0.13U W=1U
Mt7tx_Mp_f23 t7tx/DP t7tx/GP VDDIO VDDIO pfet L=0.13U W=1U
Mt7tx_Mp_f24 t7tx/DP t7tx/GP VDDIO VDDIO pfet L=0.13U W=1U
Mt7tx_Mp_f25 t7tx/DP t7tx/GP VDDIO VDDIO pfet L=0.13U W=1U
Mt7tx_Mp_f26 t7tx/DP t7tx/GP VDDIO VDDIO pfet L=0.13U W=1U
Mt7tx_Mp_f27 t7tx/DP t7tx/GP VDDIO VDDIO pfet L=0.13U W=1U
Mt7tx_Mp_f28 t7tx/DP t7tx/GP VDDIO VDDIO pfet L=0.13U W=1U
Mt7tx_Mp_f29 t7tx/DP t7tx/GP VDDIO VDDIO pfet L=0.13U W=1U
Mt7tx_Mp_f30 t7tx/DP t7tx/GP VDDIO VDDIO pfet L=0.13U W=1U
Mt7tx_Mp_f31 t7tx/DP t7tx/GP VDDIO VDDIO pfet L=0.13U W=1U
Mt7tx_Mp_f32 t7tx/DP t7tx/GP VDDIO VDDIO pfet L=0.13U W=1U
Mt7tx_Mp_f33 t7tx/DP t7tx/GP VDDIO VDDIO pfet L=0.13U W=1U
Mt7tx_Mp_f34 t7tx/DP t7tx/GP VDDIO VDDIO pfet L=0.13U W=1U
Mt7tx_Mp_f35 t7tx/DP t7tx/GP VDDIO VDDIO pfet L=0.13U W=1U
Mt7tx_Mp_f36 t7tx/DP t7tx/GP VDDIO VDDIO pfet L=0.13U W=1U
Mt7tx_Mp_f37 t7tx/DP t7tx/GP VDDIO VDDIO pfet L=0.13U W=1U
Mt7tx_Mp_f38 t7tx/DP t7tx/GP VDDIO VDDIO pfet L=0.13U W=1U
Mt7tx_Mp_f39 t7tx/DP t7tx/GP VDDIO VDDIO pfet L=0.13U W=1U
Mt7tx_Mp_f40 t7tx/DP t7tx/GP VDDIO VDDIO pfet L=0.13U W=1U
Mt7tx_Mp_f41 t7tx/DP t7tx/GP VDDIO VDDIO pfet L=0.13U W=1U
Mt7tx_Mp_f42 t7tx/DP t7tx/GP VDDIO VDDIO pfet L=0.13U W=1U
Mt7tx_Mp_f43 t7tx/DP t7tx/GP VDDIO VDDIO pfet L=0.13U W=1U
Mt7tx_Mp_f44 t7tx/DP t7tx/GP VDDIO VDDIO pfet L=0.13U W=1U
Mt7tx_Mp_f45 t7tx/DP t7tx/GP VDDIO VDDIO pfet L=0.13U W=1U
Mt7tx_Mp_f46 t7tx/DP t7tx/GP VDDIO VDDIO pfet L=0.13U W=1U
Mt7tx_Mp_f47 t7tx/DP t7tx/GP VDDIO VDDIO pfet L=0.13U W=1U
Mt7tx_Mp_f48 t7tx/DP t7tx/GP VDDIO VDDIO pfet L=0.13U W=1U
Mt7tx_Mp_f49 t7tx/DP t7tx/GP VDDIO VDDIO pfet L=0.13U W=1U
Mt7tx_Mp_f50 t7tx/DP t7tx/GP VDDIO VDDIO pfet L=0.13U W=1U
Mt7tx_Mp_f51 t7tx/DP t7tx/GP VDDIO VDDIO pfet L=0.13U W=1U
Mt7tx_Mp_f52 t7tx/DP t7tx/GP VDDIO VDDIO pfet L=0.13U W=1U
Mt7tx_Mp_f53 t7tx/DP t7tx/GP VDDIO VDDIO pfet L=0.13U W=1U
Mt7tx_Mn_f0 t7tx/DN t7tx/GN VSS VSS nfet L=0.13U W=1U
Mt7tx_Mn_f1 t7tx/DN t7tx/GN VSS VSS nfet L=0.13U W=1U
Mt7tx_Mn_f2 t7tx/DN t7tx/GN VSS VSS nfet L=0.13U W=1U
Mt7tx_Mn_f3 t7tx/DN t7tx/GN VSS VSS nfet L=0.13U W=1U
Mt7tx_Mn_f4 t7tx/DN t7tx/GN VSS VSS nfet L=0.13U W=1U
Mt7tx_Mn_f5 t7tx/DN t7tx/GN VSS VSS nfet L=0.13U W=1U
Mt7tx_Mn_f6 t7tx/DN t7tx/GN VSS VSS nfet L=0.13U W=1U
Mt7tx_Mn_f7 t7tx/DN t7tx/GN VSS VSS nfet L=0.13U W=1U
Mt7tx_Mn_f8 t7tx/DN t7tx/GN VSS VSS nfet L=0.13U W=1U
Mt7tx_Mn_f9 t7tx/DN t7tx/GN VSS VSS nfet L=0.13U W=1U
Mt7tx_Mn_f10 t7tx/DN t7tx/GN VSS VSS nfet L=0.13U W=1U
Mt7tx_Mn_f11 t7tx/DN t7tx/GN VSS VSS nfet L=0.13U W=1U
Mt7tx_Mn_f12 t7tx/DN t7tx/GN VSS VSS nfet L=0.13U W=1U
Mt7tx_Mn_f13 t7tx/DN t7tx/GN VSS VSS nfet L=0.13U W=1U
Mt7tx_Mn_f14 t7tx/DN t7tx/GN VSS VSS nfet L=0.13U W=1U
Mt7tx_Mn_f15 t7tx/DN t7tx/GN VSS VSS nfet L=0.13U W=1U
Mt7tx_Mn_f16 t7tx/DN t7tx/GN VSS VSS nfet L=0.13U W=1U
Mt7tx_Mn_f17 t7tx/DN t7tx/GN VSS VSS nfet L=0.13U W=1U
Mt7tx_Mn_f18 t7tx/DN t7tx/GN VSS VSS nfet L=0.13U W=1U
Mt7tx_Mn_f19 t7tx/DN t7tx/GN VSS VSS nfet L=0.13U W=1U
Mt7tx_Mn_f20 t7tx/DN t7tx/GN VSS VSS nfet L=0.13U W=1U
Mt7tx_Mn_f21 t7tx/DN t7tx/GN VSS VSS nfet L=0.13U W=1U
Mt7tx_Mpu_f0 t7tx/PUX PUN VDDIO VDDIO pfet L=0.13U W=2U
Xt7tx_Rpu t7tx/PUX PAD$15 VSS rppd r=12472.0 L=24U W=0.5U
Mt7tx_Mpd_f0 t7tx/PDX PD VSS VSS nfet L=0.13U W=1U
Xt7tx_Rpd PAD$15 t7tx/PDX VSS rppd r=12472.0 L=24U W=0.5U
Xt7tx_Rsp t7tx/DP PAD$15 VSS rppd r=20.0 L=0.5U W=10U
Xt7tx_Rsn t7tx/DN PAD$15 VSS rppd r=20.0 L=0.5U W=10U
Dt8esd_Dp1 PAD$17 VDDIO diodevdd_mod A=35P P=58.08U
Dt8esd_Dp1_dsub VSS VDDIO dsub_2kv_mod A=224.956P P=81.12U
Mt8esd_Mn1_f0 PAD$17 VSS VSS VSS nfet L=0.13U W=2U
Mt8esd_Mn1_f1 PAD$17 VSS VSS VSS nfet L=0.13U W=2U
Mt8esd_Mn1_f2 PAD$17 VSS VSS VSS nfet L=0.13U W=2U
Mt8esd_Mn1_f3 PAD$17 VSS VSS VSS nfet L=0.13U W=2U
Mt8esd_Mn1_f4 PAD$17 VSS VSS VSS nfet L=0.13U W=2U
Mt8esd_Mn1_f5 PAD$17 VSS VSS VSS nfet L=0.13U W=2U
Mt8esd_Mn1_f6 PAD$17 VSS VSS VSS nfet L=0.13U W=2U
Mt8esd_Mn1_f7 PAD$17 VSS VSS VSS nfet L=0.13U W=2U
Mt8esd_Mn1_f8 PAD$17 VSS VSS VSS nfet L=0.13U W=2U
Mt8esd_Mn1_f9 PAD$17 VSS VSS VSS nfet L=0.13U W=2U
Mt8esd_Mclamp_f0 VDDIO VSS VSS VSS nfet L=0.35U W=2U
Mt8esd_Mclamp_f1 VDDIO VSS VSS VSS nfet L=0.35U W=2U
Mt8esd_Mclamp_f2 VDDIO VSS VSS VSS nfet L=0.35U W=2U
Mt8esd_Mclamp_f3 VDDIO VSS VSS VSS nfet L=0.35U W=2U
Mt8esd_Mclamp_f4 VDDIO VSS VSS VSS nfet L=0.35U W=2U
Mt8esd_Mclamp_f5 VDDIO VSS VSS VSS nfet L=0.35U W=2U
Mt8esd_Mclamp_f6 VDDIO VSS VSS VSS nfet L=0.35U W=2U
Mt8esd_Mclamp_f7 VDDIO VSS VSS VSS nfet L=0.35U W=2U
Mt8esd_Mclamp_f8 VDDIO VSS VSS VSS nfet L=0.35U W=2U
Mt8esd_Mclamp_f9 VDDIO VSS VSS VSS nfet L=0.35U W=2U
Mt8esd_Mclamp_f10 VDDIO VSS VSS VSS nfet L=0.35U W=2U
Mt8esd_Mclamp_f11 VDDIO VSS VSS VSS nfet L=0.35U W=2U
Mt8esd_Mclamp_f12 VDDIO VSS VSS VSS nfet L=0.35U W=2U
Mt8esd_Mclamp_f13 VDDIO VSS VSS VSS nfet L=0.35U W=2U
Mt8esd_Mclamp_f14 VDDIO VSS VSS VSS nfet L=0.35U W=2U
Mt8esd_Mclamp_f15 VDDIO VSS VSS VSS nfet L=0.35U W=2U
Mt8esd_Mclamp_f16 VDDIO VSS VSS VSS nfet L=0.35U W=2U
Mt8esd_Mclamp_f17 VDDIO VSS VSS VSS nfet L=0.35U W=2U
Mt8esd_Mclamp_f18 VDDIO VSS VSS VSS nfet L=0.35U W=2U
Mt8esd_Mclamp_f19 VDDIO VSS VSS VSS nfet L=0.35U W=2U
Xt8esd_Resd PAD$17 PADI_T8 VSS rppd r=164.6 L=1U W=2U
Dt8esd_Dp2 PADI_T8 VDDIO dpantenna A=4P P=8U
Mt8esd_Mn2_f0 PADI_T8 VSS VSS VSS nfet L=0.13U W=1U
Mt8tx_Mi1p_f0 t8tx/OEB OE VDDIO VDDIO pfet L=0.13U W=2U
Mt8tx_Mi1n_f0 t8tx/OEB OE VSS VSS nfet L=0.13U W=1U
Mt8tx_Mnd1p_f0 t8tx/GP DIN$8 VDDIO VDDIO pfet L=0.13U W=2U
Mt8tx_Mnd1p_f1 t8tx/GP DIN$8 VDDIO VDDIO pfet L=0.13U W=2U
Mt8tx_Mnd2p_f0 t8tx/GP OE VDDIO VDDIO pfet L=0.13U W=2U
Mt8tx_Mnd2p_f1 t8tx/GP OE VDDIO VDDIO pfet L=0.13U W=2U
Mt8tx_Mnd1n_f0 t8tx/GP DIN$8 t8tx/NA VSS nfet L=0.13U W=2U
Mt8tx_Mnd1n_f1 t8tx/GP DIN$8 t8tx/NA VSS nfet L=0.13U W=2U
Mt8tx_Mnd2n_f0 t8tx/NA OE VSS VSS nfet L=0.13U W=2U
Mt8tx_Mnd2n_f1 t8tx/NA OE VSS VSS nfet L=0.13U W=2U
Mt8tx_Mnr1p_f0 t8tx/NB DIN$8 VDDIO VDDIO pfet L=0.13U W=2U
Mt8tx_Mnr1p_f1 t8tx/NB DIN$8 VDDIO VDDIO pfet L=0.13U W=2U
Mt8tx_Mnr1p_f2 t8tx/NB DIN$8 VDDIO VDDIO pfet L=0.13U W=2U
Mt8tx_Mnr1p_f3 t8tx/NB DIN$8 VDDIO VDDIO pfet L=0.13U W=2U
Mt8tx_Mnr2p_f0 t8tx/GN t8tx/OEB t8tx/NB VDDIO pfet L=0.13U W=2U
Mt8tx_Mnr2p_f1 t8tx/GN t8tx/OEB t8tx/NB VDDIO pfet L=0.13U W=2U
Mt8tx_Mnr2p_f2 t8tx/GN t8tx/OEB t8tx/NB VDDIO pfet L=0.13U W=2U
Mt8tx_Mnr2p_f3 t8tx/GN t8tx/OEB t8tx/NB VDDIO pfet L=0.13U W=2U
Mt8tx_Mnr1n_f0 t8tx/GN DIN$8 VSS VSS nfet L=0.13U W=1U
Mt8tx_Mnr1n_f1 t8tx/GN DIN$8 VSS VSS nfet L=0.13U W=1U
Mt8tx_Mnr2n_f0 t8tx/GN t8tx/OEB VSS VSS nfet L=0.13U W=1U
Mt8tx_Mnr2n_f1 t8tx/GN t8tx/OEB VSS VSS nfet L=0.13U W=1U
Mt8tx_Mp_f0 t8tx/DP t8tx/GP VDDIO VDDIO pfet L=0.13U W=1U
Mt8tx_Mp_f1 t8tx/DP t8tx/GP VDDIO VDDIO pfet L=0.13U W=1U
Mt8tx_Mp_f2 t8tx/DP t8tx/GP VDDIO VDDIO pfet L=0.13U W=1U
Mt8tx_Mp_f3 t8tx/DP t8tx/GP VDDIO VDDIO pfet L=0.13U W=1U
Mt8tx_Mp_f4 t8tx/DP t8tx/GP VDDIO VDDIO pfet L=0.13U W=1U
Mt8tx_Mp_f5 t8tx/DP t8tx/GP VDDIO VDDIO pfet L=0.13U W=1U
Mt8tx_Mp_f6 t8tx/DP t8tx/GP VDDIO VDDIO pfet L=0.13U W=1U
Mt8tx_Mp_f7 t8tx/DP t8tx/GP VDDIO VDDIO pfet L=0.13U W=1U
Mt8tx_Mp_f8 t8tx/DP t8tx/GP VDDIO VDDIO pfet L=0.13U W=1U
Mt8tx_Mp_f9 t8tx/DP t8tx/GP VDDIO VDDIO pfet L=0.13U W=1U
Mt8tx_Mp_f10 t8tx/DP t8tx/GP VDDIO VDDIO pfet L=0.13U W=1U
Mt8tx_Mp_f11 t8tx/DP t8tx/GP VDDIO VDDIO pfet L=0.13U W=1U
Mt8tx_Mp_f12 t8tx/DP t8tx/GP VDDIO VDDIO pfet L=0.13U W=1U
Mt8tx_Mp_f13 t8tx/DP t8tx/GP VDDIO VDDIO pfet L=0.13U W=1U
Mt8tx_Mp_f14 t8tx/DP t8tx/GP VDDIO VDDIO pfet L=0.13U W=1U
Mt8tx_Mp_f15 t8tx/DP t8tx/GP VDDIO VDDIO pfet L=0.13U W=1U
Mt8tx_Mp_f16 t8tx/DP t8tx/GP VDDIO VDDIO pfet L=0.13U W=1U
Mt8tx_Mp_f17 t8tx/DP t8tx/GP VDDIO VDDIO pfet L=0.13U W=1U
Mt8tx_Mp_f18 t8tx/DP t8tx/GP VDDIO VDDIO pfet L=0.13U W=1U
Mt8tx_Mp_f19 t8tx/DP t8tx/GP VDDIO VDDIO pfet L=0.13U W=1U
Mt8tx_Mp_f20 t8tx/DP t8tx/GP VDDIO VDDIO pfet L=0.13U W=1U
Mt8tx_Mp_f21 t8tx/DP t8tx/GP VDDIO VDDIO pfet L=0.13U W=1U
Mt8tx_Mp_f22 t8tx/DP t8tx/GP VDDIO VDDIO pfet L=0.13U W=1U
Mt8tx_Mp_f23 t8tx/DP t8tx/GP VDDIO VDDIO pfet L=0.13U W=1U
Mt8tx_Mp_f24 t8tx/DP t8tx/GP VDDIO VDDIO pfet L=0.13U W=1U
Mt8tx_Mp_f25 t8tx/DP t8tx/GP VDDIO VDDIO pfet L=0.13U W=1U
Mt8tx_Mp_f26 t8tx/DP t8tx/GP VDDIO VDDIO pfet L=0.13U W=1U
Mt8tx_Mp_f27 t8tx/DP t8tx/GP VDDIO VDDIO pfet L=0.13U W=1U
Mt8tx_Mp_f28 t8tx/DP t8tx/GP VDDIO VDDIO pfet L=0.13U W=1U
Mt8tx_Mp_f29 t8tx/DP t8tx/GP VDDIO VDDIO pfet L=0.13U W=1U
Mt8tx_Mp_f30 t8tx/DP t8tx/GP VDDIO VDDIO pfet L=0.13U W=1U
Mt8tx_Mp_f31 t8tx/DP t8tx/GP VDDIO VDDIO pfet L=0.13U W=1U
Mt8tx_Mp_f32 t8tx/DP t8tx/GP VDDIO VDDIO pfet L=0.13U W=1U
Mt8tx_Mp_f33 t8tx/DP t8tx/GP VDDIO VDDIO pfet L=0.13U W=1U
Mt8tx_Mp_f34 t8tx/DP t8tx/GP VDDIO VDDIO pfet L=0.13U W=1U
Mt8tx_Mp_f35 t8tx/DP t8tx/GP VDDIO VDDIO pfet L=0.13U W=1U
Mt8tx_Mp_f36 t8tx/DP t8tx/GP VDDIO VDDIO pfet L=0.13U W=1U
Mt8tx_Mp_f37 t8tx/DP t8tx/GP VDDIO VDDIO pfet L=0.13U W=1U
Mt8tx_Mp_f38 t8tx/DP t8tx/GP VDDIO VDDIO pfet L=0.13U W=1U
Mt8tx_Mp_f39 t8tx/DP t8tx/GP VDDIO VDDIO pfet L=0.13U W=1U
Mt8tx_Mp_f40 t8tx/DP t8tx/GP VDDIO VDDIO pfet L=0.13U W=1U
Mt8tx_Mp_f41 t8tx/DP t8tx/GP VDDIO VDDIO pfet L=0.13U W=1U
Mt8tx_Mp_f42 t8tx/DP t8tx/GP VDDIO VDDIO pfet L=0.13U W=1U
Mt8tx_Mp_f43 t8tx/DP t8tx/GP VDDIO VDDIO pfet L=0.13U W=1U
Mt8tx_Mp_f44 t8tx/DP t8tx/GP VDDIO VDDIO pfet L=0.13U W=1U
Mt8tx_Mp_f45 t8tx/DP t8tx/GP VDDIO VDDIO pfet L=0.13U W=1U
Mt8tx_Mp_f46 t8tx/DP t8tx/GP VDDIO VDDIO pfet L=0.13U W=1U
Mt8tx_Mp_f47 t8tx/DP t8tx/GP VDDIO VDDIO pfet L=0.13U W=1U
Mt8tx_Mp_f48 t8tx/DP t8tx/GP VDDIO VDDIO pfet L=0.13U W=1U
Mt8tx_Mp_f49 t8tx/DP t8tx/GP VDDIO VDDIO pfet L=0.13U W=1U
Mt8tx_Mp_f50 t8tx/DP t8tx/GP VDDIO VDDIO pfet L=0.13U W=1U
Mt8tx_Mp_f51 t8tx/DP t8tx/GP VDDIO VDDIO pfet L=0.13U W=1U
Mt8tx_Mp_f52 t8tx/DP t8tx/GP VDDIO VDDIO pfet L=0.13U W=1U
Mt8tx_Mp_f53 t8tx/DP t8tx/GP VDDIO VDDIO pfet L=0.13U W=1U
Mt8tx_Mn_f0 t8tx/DN t8tx/GN VSS VSS nfet L=0.13U W=1U
Mt8tx_Mn_f1 t8tx/DN t8tx/GN VSS VSS nfet L=0.13U W=1U
Mt8tx_Mn_f2 t8tx/DN t8tx/GN VSS VSS nfet L=0.13U W=1U
Mt8tx_Mn_f3 t8tx/DN t8tx/GN VSS VSS nfet L=0.13U W=1U
Mt8tx_Mn_f4 t8tx/DN t8tx/GN VSS VSS nfet L=0.13U W=1U
Mt8tx_Mn_f5 t8tx/DN t8tx/GN VSS VSS nfet L=0.13U W=1U
Mt8tx_Mn_f6 t8tx/DN t8tx/GN VSS VSS nfet L=0.13U W=1U
Mt8tx_Mn_f7 t8tx/DN t8tx/GN VSS VSS nfet L=0.13U W=1U
Mt8tx_Mn_f8 t8tx/DN t8tx/GN VSS VSS nfet L=0.13U W=1U
Mt8tx_Mn_f9 t8tx/DN t8tx/GN VSS VSS nfet L=0.13U W=1U
Mt8tx_Mn_f10 t8tx/DN t8tx/GN VSS VSS nfet L=0.13U W=1U
Mt8tx_Mn_f11 t8tx/DN t8tx/GN VSS VSS nfet L=0.13U W=1U
Mt8tx_Mn_f12 t8tx/DN t8tx/GN VSS VSS nfet L=0.13U W=1U
Mt8tx_Mn_f13 t8tx/DN t8tx/GN VSS VSS nfet L=0.13U W=1U
Mt8tx_Mn_f14 t8tx/DN t8tx/GN VSS VSS nfet L=0.13U W=1U
Mt8tx_Mn_f15 t8tx/DN t8tx/GN VSS VSS nfet L=0.13U W=1U
Mt8tx_Mn_f16 t8tx/DN t8tx/GN VSS VSS nfet L=0.13U W=1U
Mt8tx_Mn_f17 t8tx/DN t8tx/GN VSS VSS nfet L=0.13U W=1U
Mt8tx_Mn_f18 t8tx/DN t8tx/GN VSS VSS nfet L=0.13U W=1U
Mt8tx_Mn_f19 t8tx/DN t8tx/GN VSS VSS nfet L=0.13U W=1U
Mt8tx_Mn_f20 t8tx/DN t8tx/GN VSS VSS nfet L=0.13U W=1U
Mt8tx_Mn_f21 t8tx/DN t8tx/GN VSS VSS nfet L=0.13U W=1U
Mt8tx_Mpu_f0 t8tx/PUX PUN VDDIO VDDIO pfet L=0.13U W=2U
Xt8tx_Rpu t8tx/PUX PAD$17 VSS rppd r=12472.0 L=24U W=0.5U
Mt8tx_Mpd_f0 t8tx/PDX PD VSS VSS nfet L=0.13U W=1U
Xt8tx_Rpd PAD$17 t8tx/PDX VSS rppd r=12472.0 L=24U W=0.5U
Xt8tx_Rsp t8tx/DP PAD$17 VSS rppd r=20.0 L=0.5U W=10U
Xt8tx_Rsn t8tx/DN PAD$17 VSS rppd r=20.0 L=0.5U W=10U
Dt9esd_Dp1 PAD$19 VDDIO diodevdd_mod A=35P P=58.08U
Dt9esd_Dp1_dsub VSS VDDIO dsub_2kv_mod A=224.956P P=81.12U
Mt9esd_Mn1_f0 PAD$19 VSS VSS VSS nfet L=0.13U W=2U
Mt9esd_Mn1_f1 PAD$19 VSS VSS VSS nfet L=0.13U W=2U
Mt9esd_Mn1_f2 PAD$19 VSS VSS VSS nfet L=0.13U W=2U
Mt9esd_Mn1_f3 PAD$19 VSS VSS VSS nfet L=0.13U W=2U
Mt9esd_Mn1_f4 PAD$19 VSS VSS VSS nfet L=0.13U W=2U
Mt9esd_Mn1_f5 PAD$19 VSS VSS VSS nfet L=0.13U W=2U
Mt9esd_Mn1_f6 PAD$19 VSS VSS VSS nfet L=0.13U W=2U
Mt9esd_Mn1_f7 PAD$19 VSS VSS VSS nfet L=0.13U W=2U
Mt9esd_Mn1_f8 PAD$19 VSS VSS VSS nfet L=0.13U W=2U
Mt9esd_Mn1_f9 PAD$19 VSS VSS VSS nfet L=0.13U W=2U
Mt9esd_Mclamp_f0 VDDIO VSS VSS VSS nfet L=0.35U W=2U
Mt9esd_Mclamp_f1 VDDIO VSS VSS VSS nfet L=0.35U W=2U
Mt9esd_Mclamp_f2 VDDIO VSS VSS VSS nfet L=0.35U W=2U
Mt9esd_Mclamp_f3 VDDIO VSS VSS VSS nfet L=0.35U W=2U
Mt9esd_Mclamp_f4 VDDIO VSS VSS VSS nfet L=0.35U W=2U
Mt9esd_Mclamp_f5 VDDIO VSS VSS VSS nfet L=0.35U W=2U
Mt9esd_Mclamp_f6 VDDIO VSS VSS VSS nfet L=0.35U W=2U
Mt9esd_Mclamp_f7 VDDIO VSS VSS VSS nfet L=0.35U W=2U
Mt9esd_Mclamp_f8 VDDIO VSS VSS VSS nfet L=0.35U W=2U
Mt9esd_Mclamp_f9 VDDIO VSS VSS VSS nfet L=0.35U W=2U
Mt9esd_Mclamp_f10 VDDIO VSS VSS VSS nfet L=0.35U W=2U
Mt9esd_Mclamp_f11 VDDIO VSS VSS VSS nfet L=0.35U W=2U
Mt9esd_Mclamp_f12 VDDIO VSS VSS VSS nfet L=0.35U W=2U
Mt9esd_Mclamp_f13 VDDIO VSS VSS VSS nfet L=0.35U W=2U
Mt9esd_Mclamp_f14 VDDIO VSS VSS VSS nfet L=0.35U W=2U
Mt9esd_Mclamp_f15 VDDIO VSS VSS VSS nfet L=0.35U W=2U
Mt9esd_Mclamp_f16 VDDIO VSS VSS VSS nfet L=0.35U W=2U
Mt9esd_Mclamp_f17 VDDIO VSS VSS VSS nfet L=0.35U W=2U
Mt9esd_Mclamp_f18 VDDIO VSS VSS VSS nfet L=0.35U W=2U
Mt9esd_Mclamp_f19 VDDIO VSS VSS VSS nfet L=0.35U W=2U
Xt9esd_Resd PAD$19 PADI_T9 VSS rppd r=164.6 L=1U W=2U
Dt9esd_Dp2 PADI_T9 VDDIO dpantenna A=4P P=8U
Mt9esd_Mn2_f0 PADI_T9 VSS VSS VSS nfet L=0.13U W=1U
Mt9tx_Mi1p_f0 t9tx/OEB OE VDDIO VDDIO pfet L=0.13U W=2U
Mt9tx_Mi1n_f0 t9tx/OEB OE VSS VSS nfet L=0.13U W=1U
Mt9tx_Mnd1p_f0 t9tx/GP DIN$9 VDDIO VDDIO pfet L=0.13U W=2U
Mt9tx_Mnd1p_f1 t9tx/GP DIN$9 VDDIO VDDIO pfet L=0.13U W=2U
Mt9tx_Mnd2p_f0 t9tx/GP OE VDDIO VDDIO pfet L=0.13U W=2U
Mt9tx_Mnd2p_f1 t9tx/GP OE VDDIO VDDIO pfet L=0.13U W=2U
Mt9tx_Mnd1n_f0 t9tx/GP DIN$9 t9tx/NA VSS nfet L=0.13U W=2U
Mt9tx_Mnd1n_f1 t9tx/GP DIN$9 t9tx/NA VSS nfet L=0.13U W=2U
Mt9tx_Mnd2n_f0 t9tx/NA OE VSS VSS nfet L=0.13U W=2U
Mt9tx_Mnd2n_f1 t9tx/NA OE VSS VSS nfet L=0.13U W=2U
Mt9tx_Mnr1p_f0 t9tx/NB DIN$9 VDDIO VDDIO pfet L=0.13U W=2U
Mt9tx_Mnr1p_f1 t9tx/NB DIN$9 VDDIO VDDIO pfet L=0.13U W=2U
Mt9tx_Mnr1p_f2 t9tx/NB DIN$9 VDDIO VDDIO pfet L=0.13U W=2U
Mt9tx_Mnr1p_f3 t9tx/NB DIN$9 VDDIO VDDIO pfet L=0.13U W=2U
Mt9tx_Mnr2p_f0 t9tx/GN t9tx/OEB t9tx/NB VDDIO pfet L=0.13U W=2U
Mt9tx_Mnr2p_f1 t9tx/GN t9tx/OEB t9tx/NB VDDIO pfet L=0.13U W=2U
Mt9tx_Mnr2p_f2 t9tx/GN t9tx/OEB t9tx/NB VDDIO pfet L=0.13U W=2U
Mt9tx_Mnr2p_f3 t9tx/GN t9tx/OEB t9tx/NB VDDIO pfet L=0.13U W=2U
Mt9tx_Mnr1n_f0 t9tx/GN DIN$9 VSS VSS nfet L=0.13U W=1U
Mt9tx_Mnr1n_f1 t9tx/GN DIN$9 VSS VSS nfet L=0.13U W=1U
Mt9tx_Mnr2n_f0 t9tx/GN t9tx/OEB VSS VSS nfet L=0.13U W=1U
Mt9tx_Mnr2n_f1 t9tx/GN t9tx/OEB VSS VSS nfet L=0.13U W=1U
Mt9tx_Mp_f0 t9tx/DP t9tx/GP VDDIO VDDIO pfet L=0.13U W=1U
Mt9tx_Mp_f1 t9tx/DP t9tx/GP VDDIO VDDIO pfet L=0.13U W=1U
Mt9tx_Mp_f2 t9tx/DP t9tx/GP VDDIO VDDIO pfet L=0.13U W=1U
Mt9tx_Mp_f3 t9tx/DP t9tx/GP VDDIO VDDIO pfet L=0.13U W=1U
Mt9tx_Mp_f4 t9tx/DP t9tx/GP VDDIO VDDIO pfet L=0.13U W=1U
Mt9tx_Mp_f5 t9tx/DP t9tx/GP VDDIO VDDIO pfet L=0.13U W=1U
Mt9tx_Mp_f6 t9tx/DP t9tx/GP VDDIO VDDIO pfet L=0.13U W=1U
Mt9tx_Mp_f7 t9tx/DP t9tx/GP VDDIO VDDIO pfet L=0.13U W=1U
Mt9tx_Mp_f8 t9tx/DP t9tx/GP VDDIO VDDIO pfet L=0.13U W=1U
Mt9tx_Mp_f9 t9tx/DP t9tx/GP VDDIO VDDIO pfet L=0.13U W=1U
Mt9tx_Mp_f10 t9tx/DP t9tx/GP VDDIO VDDIO pfet L=0.13U W=1U
Mt9tx_Mp_f11 t9tx/DP t9tx/GP VDDIO VDDIO pfet L=0.13U W=1U
Mt9tx_Mp_f12 t9tx/DP t9tx/GP VDDIO VDDIO pfet L=0.13U W=1U
Mt9tx_Mp_f13 t9tx/DP t9tx/GP VDDIO VDDIO pfet L=0.13U W=1U
Mt9tx_Mp_f14 t9tx/DP t9tx/GP VDDIO VDDIO pfet L=0.13U W=1U
Mt9tx_Mp_f15 t9tx/DP t9tx/GP VDDIO VDDIO pfet L=0.13U W=1U
Mt9tx_Mp_f16 t9tx/DP t9tx/GP VDDIO VDDIO pfet L=0.13U W=1U
Mt9tx_Mp_f17 t9tx/DP t9tx/GP VDDIO VDDIO pfet L=0.13U W=1U
Mt9tx_Mp_f18 t9tx/DP t9tx/GP VDDIO VDDIO pfet L=0.13U W=1U
Mt9tx_Mp_f19 t9tx/DP t9tx/GP VDDIO VDDIO pfet L=0.13U W=1U
Mt9tx_Mp_f20 t9tx/DP t9tx/GP VDDIO VDDIO pfet L=0.13U W=1U
Mt9tx_Mp_f21 t9tx/DP t9tx/GP VDDIO VDDIO pfet L=0.13U W=1U
Mt9tx_Mp_f22 t9tx/DP t9tx/GP VDDIO VDDIO pfet L=0.13U W=1U
Mt9tx_Mp_f23 t9tx/DP t9tx/GP VDDIO VDDIO pfet L=0.13U W=1U
Mt9tx_Mp_f24 t9tx/DP t9tx/GP VDDIO VDDIO pfet L=0.13U W=1U
Mt9tx_Mp_f25 t9tx/DP t9tx/GP VDDIO VDDIO pfet L=0.13U W=1U
Mt9tx_Mp_f26 t9tx/DP t9tx/GP VDDIO VDDIO pfet L=0.13U W=1U
Mt9tx_Mp_f27 t9tx/DP t9tx/GP VDDIO VDDIO pfet L=0.13U W=1U
Mt9tx_Mp_f28 t9tx/DP t9tx/GP VDDIO VDDIO pfet L=0.13U W=1U
Mt9tx_Mp_f29 t9tx/DP t9tx/GP VDDIO VDDIO pfet L=0.13U W=1U
Mt9tx_Mp_f30 t9tx/DP t9tx/GP VDDIO VDDIO pfet L=0.13U W=1U
Mt9tx_Mp_f31 t9tx/DP t9tx/GP VDDIO VDDIO pfet L=0.13U W=1U
Mt9tx_Mp_f32 t9tx/DP t9tx/GP VDDIO VDDIO pfet L=0.13U W=1U
Mt9tx_Mp_f33 t9tx/DP t9tx/GP VDDIO VDDIO pfet L=0.13U W=1U
Mt9tx_Mp_f34 t9tx/DP t9tx/GP VDDIO VDDIO pfet L=0.13U W=1U
Mt9tx_Mp_f35 t9tx/DP t9tx/GP VDDIO VDDIO pfet L=0.13U W=1U
Mt9tx_Mp_f36 t9tx/DP t9tx/GP VDDIO VDDIO pfet L=0.13U W=1U
Mt9tx_Mp_f37 t9tx/DP t9tx/GP VDDIO VDDIO pfet L=0.13U W=1U
Mt9tx_Mp_f38 t9tx/DP t9tx/GP VDDIO VDDIO pfet L=0.13U W=1U
Mt9tx_Mp_f39 t9tx/DP t9tx/GP VDDIO VDDIO pfet L=0.13U W=1U
Mt9tx_Mp_f40 t9tx/DP t9tx/GP VDDIO VDDIO pfet L=0.13U W=1U
Mt9tx_Mp_f41 t9tx/DP t9tx/GP VDDIO VDDIO pfet L=0.13U W=1U
Mt9tx_Mp_f42 t9tx/DP t9tx/GP VDDIO VDDIO pfet L=0.13U W=1U
Mt9tx_Mp_f43 t9tx/DP t9tx/GP VDDIO VDDIO pfet L=0.13U W=1U
Mt9tx_Mp_f44 t9tx/DP t9tx/GP VDDIO VDDIO pfet L=0.13U W=1U
Mt9tx_Mp_f45 t9tx/DP t9tx/GP VDDIO VDDIO pfet L=0.13U W=1U
Mt9tx_Mp_f46 t9tx/DP t9tx/GP VDDIO VDDIO pfet L=0.13U W=1U
Mt9tx_Mp_f47 t9tx/DP t9tx/GP VDDIO VDDIO pfet L=0.13U W=1U
Mt9tx_Mp_f48 t9tx/DP t9tx/GP VDDIO VDDIO pfet L=0.13U W=1U
Mt9tx_Mp_f49 t9tx/DP t9tx/GP VDDIO VDDIO pfet L=0.13U W=1U
Mt9tx_Mp_f50 t9tx/DP t9tx/GP VDDIO VDDIO pfet L=0.13U W=1U
Mt9tx_Mp_f51 t9tx/DP t9tx/GP VDDIO VDDIO pfet L=0.13U W=1U
Mt9tx_Mp_f52 t9tx/DP t9tx/GP VDDIO VDDIO pfet L=0.13U W=1U
Mt9tx_Mp_f53 t9tx/DP t9tx/GP VDDIO VDDIO pfet L=0.13U W=1U
Mt9tx_Mn_f0 t9tx/DN t9tx/GN VSS VSS nfet L=0.13U W=1U
Mt9tx_Mn_f1 t9tx/DN t9tx/GN VSS VSS nfet L=0.13U W=1U
Mt9tx_Mn_f2 t9tx/DN t9tx/GN VSS VSS nfet L=0.13U W=1U
Mt9tx_Mn_f3 t9tx/DN t9tx/GN VSS VSS nfet L=0.13U W=1U
Mt9tx_Mn_f4 t9tx/DN t9tx/GN VSS VSS nfet L=0.13U W=1U
Mt9tx_Mn_f5 t9tx/DN t9tx/GN VSS VSS nfet L=0.13U W=1U
Mt9tx_Mn_f6 t9tx/DN t9tx/GN VSS VSS nfet L=0.13U W=1U
Mt9tx_Mn_f7 t9tx/DN t9tx/GN VSS VSS nfet L=0.13U W=1U
Mt9tx_Mn_f8 t9tx/DN t9tx/GN VSS VSS nfet L=0.13U W=1U
Mt9tx_Mn_f9 t9tx/DN t9tx/GN VSS VSS nfet L=0.13U W=1U
Mt9tx_Mn_f10 t9tx/DN t9tx/GN VSS VSS nfet L=0.13U W=1U
Mt9tx_Mn_f11 t9tx/DN t9tx/GN VSS VSS nfet L=0.13U W=1U
Mt9tx_Mn_f12 t9tx/DN t9tx/GN VSS VSS nfet L=0.13U W=1U
Mt9tx_Mn_f13 t9tx/DN t9tx/GN VSS VSS nfet L=0.13U W=1U
Mt9tx_Mn_f14 t9tx/DN t9tx/GN VSS VSS nfet L=0.13U W=1U
Mt9tx_Mn_f15 t9tx/DN t9tx/GN VSS VSS nfet L=0.13U W=1U
Mt9tx_Mn_f16 t9tx/DN t9tx/GN VSS VSS nfet L=0.13U W=1U
Mt9tx_Mn_f17 t9tx/DN t9tx/GN VSS VSS nfet L=0.13U W=1U
Mt9tx_Mn_f18 t9tx/DN t9tx/GN VSS VSS nfet L=0.13U W=1U
Mt9tx_Mn_f19 t9tx/DN t9tx/GN VSS VSS nfet L=0.13U W=1U
Mt9tx_Mn_f20 t9tx/DN t9tx/GN VSS VSS nfet L=0.13U W=1U
Mt9tx_Mn_f21 t9tx/DN t9tx/GN VSS VSS nfet L=0.13U W=1U
Mt9tx_Mpu_f0 t9tx/PUX PUN VDDIO VDDIO pfet L=0.13U W=2U
Xt9tx_Rpu t9tx/PUX PAD$19 VSS rppd r=12472.0 L=24U W=0.5U
Mt9tx_Mpd_f0 t9tx/PDX PD VSS VSS nfet L=0.13U W=1U
Xt9tx_Rpd PAD$19 t9tx/PDX VSS rppd r=12472.0 L=24U W=0.5U
Xt9tx_Rsp t9tx/DP PAD$19 VSS rppd r=20.0 L=0.5U W=10U
Xt9tx_Rsn t9tx/DN PAD$19 VSS rppd r=20.0 L=0.5U W=10U
Dt10esd_Dp1 PAD$21 VDDIO diodevdd_mod A=35P P=58.08U
Dt10esd_Dp1_dsub VSS VDDIO dsub_2kv_mod A=224.956P P=81.12U
Mt10esd_Mn1_f0 PAD$21 VSS VSS VSS nfet L=0.13U W=2U
Mt10esd_Mn1_f1 PAD$21 VSS VSS VSS nfet L=0.13U W=2U
Mt10esd_Mn1_f2 PAD$21 VSS VSS VSS nfet L=0.13U W=2U
Mt10esd_Mn1_f3 PAD$21 VSS VSS VSS nfet L=0.13U W=2U
Mt10esd_Mn1_f4 PAD$21 VSS VSS VSS nfet L=0.13U W=2U
Mt10esd_Mn1_f5 PAD$21 VSS VSS VSS nfet L=0.13U W=2U
Mt10esd_Mn1_f6 PAD$21 VSS VSS VSS nfet L=0.13U W=2U
Mt10esd_Mn1_f7 PAD$21 VSS VSS VSS nfet L=0.13U W=2U
Mt10esd_Mn1_f8 PAD$21 VSS VSS VSS nfet L=0.13U W=2U
Mt10esd_Mn1_f9 PAD$21 VSS VSS VSS nfet L=0.13U W=2U
Mt10esd_Mclamp_f0 VDDIO VSS VSS VSS nfet L=0.35U W=2U
Mt10esd_Mclamp_f1 VDDIO VSS VSS VSS nfet L=0.35U W=2U
Mt10esd_Mclamp_f2 VDDIO VSS VSS VSS nfet L=0.35U W=2U
Mt10esd_Mclamp_f3 VDDIO VSS VSS VSS nfet L=0.35U W=2U
Mt10esd_Mclamp_f4 VDDIO VSS VSS VSS nfet L=0.35U W=2U
Mt10esd_Mclamp_f5 VDDIO VSS VSS VSS nfet L=0.35U W=2U
Mt10esd_Mclamp_f6 VDDIO VSS VSS VSS nfet L=0.35U W=2U
Mt10esd_Mclamp_f7 VDDIO VSS VSS VSS nfet L=0.35U W=2U
Mt10esd_Mclamp_f8 VDDIO VSS VSS VSS nfet L=0.35U W=2U
Mt10esd_Mclamp_f9 VDDIO VSS VSS VSS nfet L=0.35U W=2U
Mt10esd_Mclamp_f10 VDDIO VSS VSS VSS nfet L=0.35U W=2U
Mt10esd_Mclamp_f11 VDDIO VSS VSS VSS nfet L=0.35U W=2U
Mt10esd_Mclamp_f12 VDDIO VSS VSS VSS nfet L=0.35U W=2U
Mt10esd_Mclamp_f13 VDDIO VSS VSS VSS nfet L=0.35U W=2U
Mt10esd_Mclamp_f14 VDDIO VSS VSS VSS nfet L=0.35U W=2U
Mt10esd_Mclamp_f15 VDDIO VSS VSS VSS nfet L=0.35U W=2U
Mt10esd_Mclamp_f16 VDDIO VSS VSS VSS nfet L=0.35U W=2U
Mt10esd_Mclamp_f17 VDDIO VSS VSS VSS nfet L=0.35U W=2U
Mt10esd_Mclamp_f18 VDDIO VSS VSS VSS nfet L=0.35U W=2U
Mt10esd_Mclamp_f19 VDDIO VSS VSS VSS nfet L=0.35U W=2U
Xt10esd_Resd PAD$21 PADI_T10 VSS rppd r=164.6 L=1U W=2U
Dt10esd_Dp2 PADI_T10 VDDIO dpantenna A=4P P=8U
Mt10esd_Mn2_f0 PADI_T10 VSS VSS VSS nfet L=0.13U W=1U
Mt10tx_Mi1p_f0 t10tx/OEB OE VDDIO VDDIO pfet L=0.13U W=2U
Mt10tx_Mi1n_f0 t10tx/OEB OE VSS VSS nfet L=0.13U W=1U
Mt10tx_Mnd1p_f0 t10tx/GP DIN$10 VDDIO VDDIO pfet L=0.13U W=2U
Mt10tx_Mnd1p_f1 t10tx/GP DIN$10 VDDIO VDDIO pfet L=0.13U W=2U
Mt10tx_Mnd2p_f0 t10tx/GP OE VDDIO VDDIO pfet L=0.13U W=2U
Mt10tx_Mnd2p_f1 t10tx/GP OE VDDIO VDDIO pfet L=0.13U W=2U
Mt10tx_Mnd1n_f0 t10tx/GP DIN$10 t10tx/NA VSS nfet L=0.13U W=2U
Mt10tx_Mnd1n_f1 t10tx/GP DIN$10 t10tx/NA VSS nfet L=0.13U W=2U
Mt10tx_Mnd2n_f0 t10tx/NA OE VSS VSS nfet L=0.13U W=2U
Mt10tx_Mnd2n_f1 t10tx/NA OE VSS VSS nfet L=0.13U W=2U
Mt10tx_Mnr1p_f0 t10tx/NB DIN$10 VDDIO VDDIO pfet L=0.13U W=2U
Mt10tx_Mnr1p_f1 t10tx/NB DIN$10 VDDIO VDDIO pfet L=0.13U W=2U
Mt10tx_Mnr1p_f2 t10tx/NB DIN$10 VDDIO VDDIO pfet L=0.13U W=2U
Mt10tx_Mnr1p_f3 t10tx/NB DIN$10 VDDIO VDDIO pfet L=0.13U W=2U
Mt10tx_Mnr2p_f0 t10tx/GN t10tx/OEB t10tx/NB VDDIO pfet L=0.13U W=2U
Mt10tx_Mnr2p_f1 t10tx/GN t10tx/OEB t10tx/NB VDDIO pfet L=0.13U W=2U
Mt10tx_Mnr2p_f2 t10tx/GN t10tx/OEB t10tx/NB VDDIO pfet L=0.13U W=2U
Mt10tx_Mnr2p_f3 t10tx/GN t10tx/OEB t10tx/NB VDDIO pfet L=0.13U W=2U
Mt10tx_Mnr1n_f0 t10tx/GN DIN$10 VSS VSS nfet L=0.13U W=1U
Mt10tx_Mnr1n_f1 t10tx/GN DIN$10 VSS VSS nfet L=0.13U W=1U
Mt10tx_Mnr2n_f0 t10tx/GN t10tx/OEB VSS VSS nfet L=0.13U W=1U
Mt10tx_Mnr2n_f1 t10tx/GN t10tx/OEB VSS VSS nfet L=0.13U W=1U
Mt10tx_Mp_f0 t10tx/DP t10tx/GP VDDIO VDDIO pfet L=0.13U W=1U
Mt10tx_Mp_f1 t10tx/DP t10tx/GP VDDIO VDDIO pfet L=0.13U W=1U
Mt10tx_Mp_f2 t10tx/DP t10tx/GP VDDIO VDDIO pfet L=0.13U W=1U
Mt10tx_Mp_f3 t10tx/DP t10tx/GP VDDIO VDDIO pfet L=0.13U W=1U
Mt10tx_Mp_f4 t10tx/DP t10tx/GP VDDIO VDDIO pfet L=0.13U W=1U
Mt10tx_Mp_f5 t10tx/DP t10tx/GP VDDIO VDDIO pfet L=0.13U W=1U
Mt10tx_Mp_f6 t10tx/DP t10tx/GP VDDIO VDDIO pfet L=0.13U W=1U
Mt10tx_Mp_f7 t10tx/DP t10tx/GP VDDIO VDDIO pfet L=0.13U W=1U
Mt10tx_Mp_f8 t10tx/DP t10tx/GP VDDIO VDDIO pfet L=0.13U W=1U
Mt10tx_Mp_f9 t10tx/DP t10tx/GP VDDIO VDDIO pfet L=0.13U W=1U
Mt10tx_Mp_f10 t10tx/DP t10tx/GP VDDIO VDDIO pfet L=0.13U W=1U
Mt10tx_Mp_f11 t10tx/DP t10tx/GP VDDIO VDDIO pfet L=0.13U W=1U
Mt10tx_Mp_f12 t10tx/DP t10tx/GP VDDIO VDDIO pfet L=0.13U W=1U
Mt10tx_Mp_f13 t10tx/DP t10tx/GP VDDIO VDDIO pfet L=0.13U W=1U
Mt10tx_Mp_f14 t10tx/DP t10tx/GP VDDIO VDDIO pfet L=0.13U W=1U
Mt10tx_Mp_f15 t10tx/DP t10tx/GP VDDIO VDDIO pfet L=0.13U W=1U
Mt10tx_Mp_f16 t10tx/DP t10tx/GP VDDIO VDDIO pfet L=0.13U W=1U
Mt10tx_Mp_f17 t10tx/DP t10tx/GP VDDIO VDDIO pfet L=0.13U W=1U
Mt10tx_Mp_f18 t10tx/DP t10tx/GP VDDIO VDDIO pfet L=0.13U W=1U
Mt10tx_Mp_f19 t10tx/DP t10tx/GP VDDIO VDDIO pfet L=0.13U W=1U
Mt10tx_Mp_f20 t10tx/DP t10tx/GP VDDIO VDDIO pfet L=0.13U W=1U
Mt10tx_Mp_f21 t10tx/DP t10tx/GP VDDIO VDDIO pfet L=0.13U W=1U
Mt10tx_Mp_f22 t10tx/DP t10tx/GP VDDIO VDDIO pfet L=0.13U W=1U
Mt10tx_Mp_f23 t10tx/DP t10tx/GP VDDIO VDDIO pfet L=0.13U W=1U
Mt10tx_Mp_f24 t10tx/DP t10tx/GP VDDIO VDDIO pfet L=0.13U W=1U
Mt10tx_Mp_f25 t10tx/DP t10tx/GP VDDIO VDDIO pfet L=0.13U W=1U
Mt10tx_Mp_f26 t10tx/DP t10tx/GP VDDIO VDDIO pfet L=0.13U W=1U
Mt10tx_Mp_f27 t10tx/DP t10tx/GP VDDIO VDDIO pfet L=0.13U W=1U
Mt10tx_Mp_f28 t10tx/DP t10tx/GP VDDIO VDDIO pfet L=0.13U W=1U
Mt10tx_Mp_f29 t10tx/DP t10tx/GP VDDIO VDDIO pfet L=0.13U W=1U
Mt10tx_Mp_f30 t10tx/DP t10tx/GP VDDIO VDDIO pfet L=0.13U W=1U
Mt10tx_Mp_f31 t10tx/DP t10tx/GP VDDIO VDDIO pfet L=0.13U W=1U
Mt10tx_Mp_f32 t10tx/DP t10tx/GP VDDIO VDDIO pfet L=0.13U W=1U
Mt10tx_Mp_f33 t10tx/DP t10tx/GP VDDIO VDDIO pfet L=0.13U W=1U
Mt10tx_Mp_f34 t10tx/DP t10tx/GP VDDIO VDDIO pfet L=0.13U W=1U
Mt10tx_Mp_f35 t10tx/DP t10tx/GP VDDIO VDDIO pfet L=0.13U W=1U
Mt10tx_Mp_f36 t10tx/DP t10tx/GP VDDIO VDDIO pfet L=0.13U W=1U
Mt10tx_Mp_f37 t10tx/DP t10tx/GP VDDIO VDDIO pfet L=0.13U W=1U
Mt10tx_Mp_f38 t10tx/DP t10tx/GP VDDIO VDDIO pfet L=0.13U W=1U
Mt10tx_Mp_f39 t10tx/DP t10tx/GP VDDIO VDDIO pfet L=0.13U W=1U
Mt10tx_Mp_f40 t10tx/DP t10tx/GP VDDIO VDDIO pfet L=0.13U W=1U
Mt10tx_Mp_f41 t10tx/DP t10tx/GP VDDIO VDDIO pfet L=0.13U W=1U
Mt10tx_Mp_f42 t10tx/DP t10tx/GP VDDIO VDDIO pfet L=0.13U W=1U
Mt10tx_Mp_f43 t10tx/DP t10tx/GP VDDIO VDDIO pfet L=0.13U W=1U
Mt10tx_Mp_f44 t10tx/DP t10tx/GP VDDIO VDDIO pfet L=0.13U W=1U
Mt10tx_Mp_f45 t10tx/DP t10tx/GP VDDIO VDDIO pfet L=0.13U W=1U
Mt10tx_Mp_f46 t10tx/DP t10tx/GP VDDIO VDDIO pfet L=0.13U W=1U
Mt10tx_Mp_f47 t10tx/DP t10tx/GP VDDIO VDDIO pfet L=0.13U W=1U
Mt10tx_Mp_f48 t10tx/DP t10tx/GP VDDIO VDDIO pfet L=0.13U W=1U
Mt10tx_Mp_f49 t10tx/DP t10tx/GP VDDIO VDDIO pfet L=0.13U W=1U
Mt10tx_Mp_f50 t10tx/DP t10tx/GP VDDIO VDDIO pfet L=0.13U W=1U
Mt10tx_Mp_f51 t10tx/DP t10tx/GP VDDIO VDDIO pfet L=0.13U W=1U
Mt10tx_Mp_f52 t10tx/DP t10tx/GP VDDIO VDDIO pfet L=0.13U W=1U
Mt10tx_Mp_f53 t10tx/DP t10tx/GP VDDIO VDDIO pfet L=0.13U W=1U
Mt10tx_Mn_f0 t10tx/DN t10tx/GN VSS VSS nfet L=0.13U W=1U
Mt10tx_Mn_f1 t10tx/DN t10tx/GN VSS VSS nfet L=0.13U W=1U
Mt10tx_Mn_f2 t10tx/DN t10tx/GN VSS VSS nfet L=0.13U W=1U
Mt10tx_Mn_f3 t10tx/DN t10tx/GN VSS VSS nfet L=0.13U W=1U
Mt10tx_Mn_f4 t10tx/DN t10tx/GN VSS VSS nfet L=0.13U W=1U
Mt10tx_Mn_f5 t10tx/DN t10tx/GN VSS VSS nfet L=0.13U W=1U
Mt10tx_Mn_f6 t10tx/DN t10tx/GN VSS VSS nfet L=0.13U W=1U
Mt10tx_Mn_f7 t10tx/DN t10tx/GN VSS VSS nfet L=0.13U W=1U
Mt10tx_Mn_f8 t10tx/DN t10tx/GN VSS VSS nfet L=0.13U W=1U
Mt10tx_Mn_f9 t10tx/DN t10tx/GN VSS VSS nfet L=0.13U W=1U
Mt10tx_Mn_f10 t10tx/DN t10tx/GN VSS VSS nfet L=0.13U W=1U
Mt10tx_Mn_f11 t10tx/DN t10tx/GN VSS VSS nfet L=0.13U W=1U
Mt10tx_Mn_f12 t10tx/DN t10tx/GN VSS VSS nfet L=0.13U W=1U
Mt10tx_Mn_f13 t10tx/DN t10tx/GN VSS VSS nfet L=0.13U W=1U
Mt10tx_Mn_f14 t10tx/DN t10tx/GN VSS VSS nfet L=0.13U W=1U
Mt10tx_Mn_f15 t10tx/DN t10tx/GN VSS VSS nfet L=0.13U W=1U
Mt10tx_Mn_f16 t10tx/DN t10tx/GN VSS VSS nfet L=0.13U W=1U
Mt10tx_Mn_f17 t10tx/DN t10tx/GN VSS VSS nfet L=0.13U W=1U
Mt10tx_Mn_f18 t10tx/DN t10tx/GN VSS VSS nfet L=0.13U W=1U
Mt10tx_Mn_f19 t10tx/DN t10tx/GN VSS VSS nfet L=0.13U W=1U
Mt10tx_Mn_f20 t10tx/DN t10tx/GN VSS VSS nfet L=0.13U W=1U
Mt10tx_Mn_f21 t10tx/DN t10tx/GN VSS VSS nfet L=0.13U W=1U
Mt10tx_Mpu_f0 t10tx/PUX PUN VDDIO VDDIO pfet L=0.13U W=2U
Xt10tx_Rpu t10tx/PUX PAD$21 VSS rppd r=12472.0 L=24U W=0.5U
Mt10tx_Mpd_f0 t10tx/PDX PD VSS VSS nfet L=0.13U W=1U
Xt10tx_Rpd PAD$21 t10tx/PDX VSS rppd r=12472.0 L=24U W=0.5U
Xt10tx_Rsp t10tx/DP PAD$21 VSS rppd r=20.0 L=0.5U W=10U
Xt10tx_Rsn t10tx/DN PAD$21 VSS rppd r=20.0 L=0.5U W=10U
Dt11esd_Dp1 PAD$23 VDDIO diodevdd_mod A=35P P=58.08U
Dt11esd_Dp1_dsub VSS VDDIO dsub_2kv_mod A=224.956P P=81.12U
Mt11esd_Mn1_f0 PAD$23 VSS VSS VSS nfet L=0.13U W=2U
Mt11esd_Mn1_f1 PAD$23 VSS VSS VSS nfet L=0.13U W=2U
Mt11esd_Mn1_f2 PAD$23 VSS VSS VSS nfet L=0.13U W=2U
Mt11esd_Mn1_f3 PAD$23 VSS VSS VSS nfet L=0.13U W=2U
Mt11esd_Mn1_f4 PAD$23 VSS VSS VSS nfet L=0.13U W=2U
Mt11esd_Mn1_f5 PAD$23 VSS VSS VSS nfet L=0.13U W=2U
Mt11esd_Mn1_f6 PAD$23 VSS VSS VSS nfet L=0.13U W=2U
Mt11esd_Mn1_f7 PAD$23 VSS VSS VSS nfet L=0.13U W=2U
Mt11esd_Mn1_f8 PAD$23 VSS VSS VSS nfet L=0.13U W=2U
Mt11esd_Mn1_f9 PAD$23 VSS VSS VSS nfet L=0.13U W=2U
Mt11esd_Mclamp_f0 VDDIO VSS VSS VSS nfet L=0.35U W=2U
Mt11esd_Mclamp_f1 VDDIO VSS VSS VSS nfet L=0.35U W=2U
Mt11esd_Mclamp_f2 VDDIO VSS VSS VSS nfet L=0.35U W=2U
Mt11esd_Mclamp_f3 VDDIO VSS VSS VSS nfet L=0.35U W=2U
Mt11esd_Mclamp_f4 VDDIO VSS VSS VSS nfet L=0.35U W=2U
Mt11esd_Mclamp_f5 VDDIO VSS VSS VSS nfet L=0.35U W=2U
Mt11esd_Mclamp_f6 VDDIO VSS VSS VSS nfet L=0.35U W=2U
Mt11esd_Mclamp_f7 VDDIO VSS VSS VSS nfet L=0.35U W=2U
Mt11esd_Mclamp_f8 VDDIO VSS VSS VSS nfet L=0.35U W=2U
Mt11esd_Mclamp_f9 VDDIO VSS VSS VSS nfet L=0.35U W=2U
Mt11esd_Mclamp_f10 VDDIO VSS VSS VSS nfet L=0.35U W=2U
Mt11esd_Mclamp_f11 VDDIO VSS VSS VSS nfet L=0.35U W=2U
Mt11esd_Mclamp_f12 VDDIO VSS VSS VSS nfet L=0.35U W=2U
Mt11esd_Mclamp_f13 VDDIO VSS VSS VSS nfet L=0.35U W=2U
Mt11esd_Mclamp_f14 VDDIO VSS VSS VSS nfet L=0.35U W=2U
Mt11esd_Mclamp_f15 VDDIO VSS VSS VSS nfet L=0.35U W=2U
Mt11esd_Mclamp_f16 VDDIO VSS VSS VSS nfet L=0.35U W=2U
Mt11esd_Mclamp_f17 VDDIO VSS VSS VSS nfet L=0.35U W=2U
Mt11esd_Mclamp_f18 VDDIO VSS VSS VSS nfet L=0.35U W=2U
Mt11esd_Mclamp_f19 VDDIO VSS VSS VSS nfet L=0.35U W=2U
Xt11esd_Resd PAD$23 PADI_T11 VSS rppd r=164.6 L=1U W=2U
Dt11esd_Dp2 PADI_T11 VDDIO dpantenna A=4P P=8U
Mt11esd_Mn2_f0 PADI_T11 VSS VSS VSS nfet L=0.13U W=1U
Mt11tx_Mi1p_f0 t11tx/OEB OE VDDIO VDDIO pfet L=0.13U W=2U
Mt11tx_Mi1n_f0 t11tx/OEB OE VSS VSS nfet L=0.13U W=1U
Mt11tx_Mnd1p_f0 t11tx/GP DIN$11 VDDIO VDDIO pfet L=0.13U W=2U
Mt11tx_Mnd1p_f1 t11tx/GP DIN$11 VDDIO VDDIO pfet L=0.13U W=2U
Mt11tx_Mnd2p_f0 t11tx/GP OE VDDIO VDDIO pfet L=0.13U W=2U
Mt11tx_Mnd2p_f1 t11tx/GP OE VDDIO VDDIO pfet L=0.13U W=2U
Mt11tx_Mnd1n_f0 t11tx/GP DIN$11 t11tx/NA VSS nfet L=0.13U W=2U
Mt11tx_Mnd1n_f1 t11tx/GP DIN$11 t11tx/NA VSS nfet L=0.13U W=2U
Mt11tx_Mnd2n_f0 t11tx/NA OE VSS VSS nfet L=0.13U W=2U
Mt11tx_Mnd2n_f1 t11tx/NA OE VSS VSS nfet L=0.13U W=2U
Mt11tx_Mnr1p_f0 t11tx/NB DIN$11 VDDIO VDDIO pfet L=0.13U W=2U
Mt11tx_Mnr1p_f1 t11tx/NB DIN$11 VDDIO VDDIO pfet L=0.13U W=2U
Mt11tx_Mnr1p_f2 t11tx/NB DIN$11 VDDIO VDDIO pfet L=0.13U W=2U
Mt11tx_Mnr1p_f3 t11tx/NB DIN$11 VDDIO VDDIO pfet L=0.13U W=2U
Mt11tx_Mnr2p_f0 t11tx/GN t11tx/OEB t11tx/NB VDDIO pfet L=0.13U W=2U
Mt11tx_Mnr2p_f1 t11tx/GN t11tx/OEB t11tx/NB VDDIO pfet L=0.13U W=2U
Mt11tx_Mnr2p_f2 t11tx/GN t11tx/OEB t11tx/NB VDDIO pfet L=0.13U W=2U
Mt11tx_Mnr2p_f3 t11tx/GN t11tx/OEB t11tx/NB VDDIO pfet L=0.13U W=2U
Mt11tx_Mnr1n_f0 t11tx/GN DIN$11 VSS VSS nfet L=0.13U W=1U
Mt11tx_Mnr1n_f1 t11tx/GN DIN$11 VSS VSS nfet L=0.13U W=1U
Mt11tx_Mnr2n_f0 t11tx/GN t11tx/OEB VSS VSS nfet L=0.13U W=1U
Mt11tx_Mnr2n_f1 t11tx/GN t11tx/OEB VSS VSS nfet L=0.13U W=1U
Mt11tx_Mp_f0 t11tx/DP t11tx/GP VDDIO VDDIO pfet L=0.13U W=1U
Mt11tx_Mp_f1 t11tx/DP t11tx/GP VDDIO VDDIO pfet L=0.13U W=1U
Mt11tx_Mp_f2 t11tx/DP t11tx/GP VDDIO VDDIO pfet L=0.13U W=1U
Mt11tx_Mp_f3 t11tx/DP t11tx/GP VDDIO VDDIO pfet L=0.13U W=1U
Mt11tx_Mp_f4 t11tx/DP t11tx/GP VDDIO VDDIO pfet L=0.13U W=1U
Mt11tx_Mp_f5 t11tx/DP t11tx/GP VDDIO VDDIO pfet L=0.13U W=1U
Mt11tx_Mp_f6 t11tx/DP t11tx/GP VDDIO VDDIO pfet L=0.13U W=1U
Mt11tx_Mp_f7 t11tx/DP t11tx/GP VDDIO VDDIO pfet L=0.13U W=1U
Mt11tx_Mp_f8 t11tx/DP t11tx/GP VDDIO VDDIO pfet L=0.13U W=1U
Mt11tx_Mp_f9 t11tx/DP t11tx/GP VDDIO VDDIO pfet L=0.13U W=1U
Mt11tx_Mp_f10 t11tx/DP t11tx/GP VDDIO VDDIO pfet L=0.13U W=1U
Mt11tx_Mp_f11 t11tx/DP t11tx/GP VDDIO VDDIO pfet L=0.13U W=1U
Mt11tx_Mp_f12 t11tx/DP t11tx/GP VDDIO VDDIO pfet L=0.13U W=1U
Mt11tx_Mp_f13 t11tx/DP t11tx/GP VDDIO VDDIO pfet L=0.13U W=1U
Mt11tx_Mp_f14 t11tx/DP t11tx/GP VDDIO VDDIO pfet L=0.13U W=1U
Mt11tx_Mp_f15 t11tx/DP t11tx/GP VDDIO VDDIO pfet L=0.13U W=1U
Mt11tx_Mp_f16 t11tx/DP t11tx/GP VDDIO VDDIO pfet L=0.13U W=1U
Mt11tx_Mp_f17 t11tx/DP t11tx/GP VDDIO VDDIO pfet L=0.13U W=1U
Mt11tx_Mp_f18 t11tx/DP t11tx/GP VDDIO VDDIO pfet L=0.13U W=1U
Mt11tx_Mp_f19 t11tx/DP t11tx/GP VDDIO VDDIO pfet L=0.13U W=1U
Mt11tx_Mp_f20 t11tx/DP t11tx/GP VDDIO VDDIO pfet L=0.13U W=1U
Mt11tx_Mp_f21 t11tx/DP t11tx/GP VDDIO VDDIO pfet L=0.13U W=1U
Mt11tx_Mp_f22 t11tx/DP t11tx/GP VDDIO VDDIO pfet L=0.13U W=1U
Mt11tx_Mp_f23 t11tx/DP t11tx/GP VDDIO VDDIO pfet L=0.13U W=1U
Mt11tx_Mp_f24 t11tx/DP t11tx/GP VDDIO VDDIO pfet L=0.13U W=1U
Mt11tx_Mp_f25 t11tx/DP t11tx/GP VDDIO VDDIO pfet L=0.13U W=1U
Mt11tx_Mp_f26 t11tx/DP t11tx/GP VDDIO VDDIO pfet L=0.13U W=1U
Mt11tx_Mp_f27 t11tx/DP t11tx/GP VDDIO VDDIO pfet L=0.13U W=1U
Mt11tx_Mp_f28 t11tx/DP t11tx/GP VDDIO VDDIO pfet L=0.13U W=1U
Mt11tx_Mp_f29 t11tx/DP t11tx/GP VDDIO VDDIO pfet L=0.13U W=1U
Mt11tx_Mp_f30 t11tx/DP t11tx/GP VDDIO VDDIO pfet L=0.13U W=1U
Mt11tx_Mp_f31 t11tx/DP t11tx/GP VDDIO VDDIO pfet L=0.13U W=1U
Mt11tx_Mp_f32 t11tx/DP t11tx/GP VDDIO VDDIO pfet L=0.13U W=1U
Mt11tx_Mp_f33 t11tx/DP t11tx/GP VDDIO VDDIO pfet L=0.13U W=1U
Mt11tx_Mp_f34 t11tx/DP t11tx/GP VDDIO VDDIO pfet L=0.13U W=1U
Mt11tx_Mp_f35 t11tx/DP t11tx/GP VDDIO VDDIO pfet L=0.13U W=1U
Mt11tx_Mp_f36 t11tx/DP t11tx/GP VDDIO VDDIO pfet L=0.13U W=1U
Mt11tx_Mp_f37 t11tx/DP t11tx/GP VDDIO VDDIO pfet L=0.13U W=1U
Mt11tx_Mp_f38 t11tx/DP t11tx/GP VDDIO VDDIO pfet L=0.13U W=1U
Mt11tx_Mp_f39 t11tx/DP t11tx/GP VDDIO VDDIO pfet L=0.13U W=1U
Mt11tx_Mp_f40 t11tx/DP t11tx/GP VDDIO VDDIO pfet L=0.13U W=1U
Mt11tx_Mp_f41 t11tx/DP t11tx/GP VDDIO VDDIO pfet L=0.13U W=1U
Mt11tx_Mp_f42 t11tx/DP t11tx/GP VDDIO VDDIO pfet L=0.13U W=1U
Mt11tx_Mp_f43 t11tx/DP t11tx/GP VDDIO VDDIO pfet L=0.13U W=1U
Mt11tx_Mp_f44 t11tx/DP t11tx/GP VDDIO VDDIO pfet L=0.13U W=1U
Mt11tx_Mp_f45 t11tx/DP t11tx/GP VDDIO VDDIO pfet L=0.13U W=1U
Mt11tx_Mp_f46 t11tx/DP t11tx/GP VDDIO VDDIO pfet L=0.13U W=1U
Mt11tx_Mp_f47 t11tx/DP t11tx/GP VDDIO VDDIO pfet L=0.13U W=1U
Mt11tx_Mp_f48 t11tx/DP t11tx/GP VDDIO VDDIO pfet L=0.13U W=1U
Mt11tx_Mp_f49 t11tx/DP t11tx/GP VDDIO VDDIO pfet L=0.13U W=1U
Mt11tx_Mp_f50 t11tx/DP t11tx/GP VDDIO VDDIO pfet L=0.13U W=1U
Mt11tx_Mp_f51 t11tx/DP t11tx/GP VDDIO VDDIO pfet L=0.13U W=1U
Mt11tx_Mp_f52 t11tx/DP t11tx/GP VDDIO VDDIO pfet L=0.13U W=1U
Mt11tx_Mp_f53 t11tx/DP t11tx/GP VDDIO VDDIO pfet L=0.13U W=1U
Mt11tx_Mn_f0 t11tx/DN t11tx/GN VSS VSS nfet L=0.13U W=1U
Mt11tx_Mn_f1 t11tx/DN t11tx/GN VSS VSS nfet L=0.13U W=1U
Mt11tx_Mn_f2 t11tx/DN t11tx/GN VSS VSS nfet L=0.13U W=1U
Mt11tx_Mn_f3 t11tx/DN t11tx/GN VSS VSS nfet L=0.13U W=1U
Mt11tx_Mn_f4 t11tx/DN t11tx/GN VSS VSS nfet L=0.13U W=1U
Mt11tx_Mn_f5 t11tx/DN t11tx/GN VSS VSS nfet L=0.13U W=1U
Mt11tx_Mn_f6 t11tx/DN t11tx/GN VSS VSS nfet L=0.13U W=1U
Mt11tx_Mn_f7 t11tx/DN t11tx/GN VSS VSS nfet L=0.13U W=1U
Mt11tx_Mn_f8 t11tx/DN t11tx/GN VSS VSS nfet L=0.13U W=1U
Mt11tx_Mn_f9 t11tx/DN t11tx/GN VSS VSS nfet L=0.13U W=1U
Mt11tx_Mn_f10 t11tx/DN t11tx/GN VSS VSS nfet L=0.13U W=1U
Mt11tx_Mn_f11 t11tx/DN t11tx/GN VSS VSS nfet L=0.13U W=1U
Mt11tx_Mn_f12 t11tx/DN t11tx/GN VSS VSS nfet L=0.13U W=1U
Mt11tx_Mn_f13 t11tx/DN t11tx/GN VSS VSS nfet L=0.13U W=1U
Mt11tx_Mn_f14 t11tx/DN t11tx/GN VSS VSS nfet L=0.13U W=1U
Mt11tx_Mn_f15 t11tx/DN t11tx/GN VSS VSS nfet L=0.13U W=1U
Mt11tx_Mn_f16 t11tx/DN t11tx/GN VSS VSS nfet L=0.13U W=1U
Mt11tx_Mn_f17 t11tx/DN t11tx/GN VSS VSS nfet L=0.13U W=1U
Mt11tx_Mn_f18 t11tx/DN t11tx/GN VSS VSS nfet L=0.13U W=1U
Mt11tx_Mn_f19 t11tx/DN t11tx/GN VSS VSS nfet L=0.13U W=1U
Mt11tx_Mn_f20 t11tx/DN t11tx/GN VSS VSS nfet L=0.13U W=1U
Mt11tx_Mn_f21 t11tx/DN t11tx/GN VSS VSS nfet L=0.13U W=1U
Mt11tx_Mpu_f0 t11tx/PUX PUN VDDIO VDDIO pfet L=0.13U W=2U
Xt11tx_Rpu t11tx/PUX PAD$23 VSS rppd r=12472.0 L=24U W=0.5U
Mt11tx_Mpd_f0 t11tx/PDX PD VSS VSS nfet L=0.13U W=1U
Xt11tx_Rpd PAD$23 t11tx/PDX VSS rppd r=12472.0 L=24U W=0.5U
Xt11tx_Rsp t11tx/DP PAD$23 VSS rppd r=20.0 L=0.5U W=10U
Xt11tx_Rsn t11tx/DN PAD$23 VSS rppd r=20.0 L=0.5U W=10U
Dt12esd_Dp1 PAD VDDIO diodevdd_mod A=35P P=58.08U
Dt12esd_Dp1_dsub VSS VDDIO dsub_2kv_mod A=224.956P P=81.12U
Mt12esd_Mn1_f0 PAD VSS VSS VSS nfet L=0.13U W=2U
Mt12esd_Mn1_f1 PAD VSS VSS VSS nfet L=0.13U W=2U
Mt12esd_Mn1_f2 PAD VSS VSS VSS nfet L=0.13U W=2U
Mt12esd_Mn1_f3 PAD VSS VSS VSS nfet L=0.13U W=2U
Mt12esd_Mn1_f4 PAD VSS VSS VSS nfet L=0.13U W=2U
Mt12esd_Mn1_f5 PAD VSS VSS VSS nfet L=0.13U W=2U
Mt12esd_Mn1_f6 PAD VSS VSS VSS nfet L=0.13U W=2U
Mt12esd_Mn1_f7 PAD VSS VSS VSS nfet L=0.13U W=2U
Mt12esd_Mn1_f8 PAD VSS VSS VSS nfet L=0.13U W=2U
Mt12esd_Mn1_f9 PAD VSS VSS VSS nfet L=0.13U W=2U
Mt12esd_Mclamp_f0 VDDIO VSS VSS VSS nfet L=0.35U W=2U
Mt12esd_Mclamp_f1 VDDIO VSS VSS VSS nfet L=0.35U W=2U
Mt12esd_Mclamp_f2 VDDIO VSS VSS VSS nfet L=0.35U W=2U
Mt12esd_Mclamp_f3 VDDIO VSS VSS VSS nfet L=0.35U W=2U
Mt12esd_Mclamp_f4 VDDIO VSS VSS VSS nfet L=0.35U W=2U
Mt12esd_Mclamp_f5 VDDIO VSS VSS VSS nfet L=0.35U W=2U
Mt12esd_Mclamp_f6 VDDIO VSS VSS VSS nfet L=0.35U W=2U
Mt12esd_Mclamp_f7 VDDIO VSS VSS VSS nfet L=0.35U W=2U
Mt12esd_Mclamp_f8 VDDIO VSS VSS VSS nfet L=0.35U W=2U
Mt12esd_Mclamp_f9 VDDIO VSS VSS VSS nfet L=0.35U W=2U
Mt12esd_Mclamp_f10 VDDIO VSS VSS VSS nfet L=0.35U W=2U
Mt12esd_Mclamp_f11 VDDIO VSS VSS VSS nfet L=0.35U W=2U
Mt12esd_Mclamp_f12 VDDIO VSS VSS VSS nfet L=0.35U W=2U
Mt12esd_Mclamp_f13 VDDIO VSS VSS VSS nfet L=0.35U W=2U
Mt12esd_Mclamp_f14 VDDIO VSS VSS VSS nfet L=0.35U W=2U
Mt12esd_Mclamp_f15 VDDIO VSS VSS VSS nfet L=0.35U W=2U
Mt12esd_Mclamp_f16 VDDIO VSS VSS VSS nfet L=0.35U W=2U
Mt12esd_Mclamp_f17 VDDIO VSS VSS VSS nfet L=0.35U W=2U
Mt12esd_Mclamp_f18 VDDIO VSS VSS VSS nfet L=0.35U W=2U
Mt12esd_Mclamp_f19 VDDIO VSS VSS VSS nfet L=0.35U W=2U
Xt12esd_Resd PAD PADI_T12 VSS rppd r=164.6 L=1U W=2U
Dt12esd_Dp2 PADI_T12 VDDIO dpantenna A=4P P=8U
Mt12esd_Mn2_f0 PADI_T12 VSS VSS VSS nfet L=0.13U W=1U
Mt12tx_Mi1p_f0 t12tx/OEB OE VDDIO VDDIO pfet L=0.13U W=2U
Mt12tx_Mi1n_f0 t12tx/OEB OE VSS VSS nfet L=0.13U W=1U
Mt12tx_Mnd1p_f0 t12tx/GP DIN$12 VDDIO VDDIO pfet L=0.13U W=2U
Mt12tx_Mnd1p_f1 t12tx/GP DIN$12 VDDIO VDDIO pfet L=0.13U W=2U
Mt12tx_Mnd2p_f0 t12tx/GP OE VDDIO VDDIO pfet L=0.13U W=2U
Mt12tx_Mnd2p_f1 t12tx/GP OE VDDIO VDDIO pfet L=0.13U W=2U
Mt12tx_Mnd1n_f0 t12tx/GP DIN$12 t12tx/NA VSS nfet L=0.13U W=2U
Mt12tx_Mnd1n_f1 t12tx/GP DIN$12 t12tx/NA VSS nfet L=0.13U W=2U
Mt12tx_Mnd2n_f0 t12tx/NA OE VSS VSS nfet L=0.13U W=2U
Mt12tx_Mnd2n_f1 t12tx/NA OE VSS VSS nfet L=0.13U W=2U
Mt12tx_Mnr1p_f0 t12tx/NB DIN$12 VDDIO VDDIO pfet L=0.13U W=2U
Mt12tx_Mnr1p_f1 t12tx/NB DIN$12 VDDIO VDDIO pfet L=0.13U W=2U
Mt12tx_Mnr1p_f2 t12tx/NB DIN$12 VDDIO VDDIO pfet L=0.13U W=2U
Mt12tx_Mnr1p_f3 t12tx/NB DIN$12 VDDIO VDDIO pfet L=0.13U W=2U
Mt12tx_Mnr2p_f0 t12tx/GN t12tx/OEB t12tx/NB VDDIO pfet L=0.13U W=2U
Mt12tx_Mnr2p_f1 t12tx/GN t12tx/OEB t12tx/NB VDDIO pfet L=0.13U W=2U
Mt12tx_Mnr2p_f2 t12tx/GN t12tx/OEB t12tx/NB VDDIO pfet L=0.13U W=2U
Mt12tx_Mnr2p_f3 t12tx/GN t12tx/OEB t12tx/NB VDDIO pfet L=0.13U W=2U
Mt12tx_Mnr1n_f0 t12tx/GN DIN$12 VSS VSS nfet L=0.13U W=1U
Mt12tx_Mnr1n_f1 t12tx/GN DIN$12 VSS VSS nfet L=0.13U W=1U
Mt12tx_Mnr2n_f0 t12tx/GN t12tx/OEB VSS VSS nfet L=0.13U W=1U
Mt12tx_Mnr2n_f1 t12tx/GN t12tx/OEB VSS VSS nfet L=0.13U W=1U
Mt12tx_Mp_f0 t12tx/DP t12tx/GP VDDIO VDDIO pfet L=0.13U W=1U
Mt12tx_Mp_f1 t12tx/DP t12tx/GP VDDIO VDDIO pfet L=0.13U W=1U
Mt12tx_Mp_f2 t12tx/DP t12tx/GP VDDIO VDDIO pfet L=0.13U W=1U
Mt12tx_Mp_f3 t12tx/DP t12tx/GP VDDIO VDDIO pfet L=0.13U W=1U
Mt12tx_Mp_f4 t12tx/DP t12tx/GP VDDIO VDDIO pfet L=0.13U W=1U
Mt12tx_Mp_f5 t12tx/DP t12tx/GP VDDIO VDDIO pfet L=0.13U W=1U
Mt12tx_Mp_f6 t12tx/DP t12tx/GP VDDIO VDDIO pfet L=0.13U W=1U
Mt12tx_Mp_f7 t12tx/DP t12tx/GP VDDIO VDDIO pfet L=0.13U W=1U
Mt12tx_Mp_f8 t12tx/DP t12tx/GP VDDIO VDDIO pfet L=0.13U W=1U
Mt12tx_Mp_f9 t12tx/DP t12tx/GP VDDIO VDDIO pfet L=0.13U W=1U
Mt12tx_Mp_f10 t12tx/DP t12tx/GP VDDIO VDDIO pfet L=0.13U W=1U
Mt12tx_Mp_f11 t12tx/DP t12tx/GP VDDIO VDDIO pfet L=0.13U W=1U
Mt12tx_Mp_f12 t12tx/DP t12tx/GP VDDIO VDDIO pfet L=0.13U W=1U
Mt12tx_Mp_f13 t12tx/DP t12tx/GP VDDIO VDDIO pfet L=0.13U W=1U
Mt12tx_Mp_f14 t12tx/DP t12tx/GP VDDIO VDDIO pfet L=0.13U W=1U
Mt12tx_Mp_f15 t12tx/DP t12tx/GP VDDIO VDDIO pfet L=0.13U W=1U
Mt12tx_Mp_f16 t12tx/DP t12tx/GP VDDIO VDDIO pfet L=0.13U W=1U
Mt12tx_Mp_f17 t12tx/DP t12tx/GP VDDIO VDDIO pfet L=0.13U W=1U
Mt12tx_Mp_f18 t12tx/DP t12tx/GP VDDIO VDDIO pfet L=0.13U W=1U
Mt12tx_Mp_f19 t12tx/DP t12tx/GP VDDIO VDDIO pfet L=0.13U W=1U
Mt12tx_Mp_f20 t12tx/DP t12tx/GP VDDIO VDDIO pfet L=0.13U W=1U
Mt12tx_Mp_f21 t12tx/DP t12tx/GP VDDIO VDDIO pfet L=0.13U W=1U
Mt12tx_Mp_f22 t12tx/DP t12tx/GP VDDIO VDDIO pfet L=0.13U W=1U
Mt12tx_Mp_f23 t12tx/DP t12tx/GP VDDIO VDDIO pfet L=0.13U W=1U
Mt12tx_Mp_f24 t12tx/DP t12tx/GP VDDIO VDDIO pfet L=0.13U W=1U
Mt12tx_Mp_f25 t12tx/DP t12tx/GP VDDIO VDDIO pfet L=0.13U W=1U
Mt12tx_Mp_f26 t12tx/DP t12tx/GP VDDIO VDDIO pfet L=0.13U W=1U
Mt12tx_Mp_f27 t12tx/DP t12tx/GP VDDIO VDDIO pfet L=0.13U W=1U
Mt12tx_Mp_f28 t12tx/DP t12tx/GP VDDIO VDDIO pfet L=0.13U W=1U
Mt12tx_Mp_f29 t12tx/DP t12tx/GP VDDIO VDDIO pfet L=0.13U W=1U
Mt12tx_Mp_f30 t12tx/DP t12tx/GP VDDIO VDDIO pfet L=0.13U W=1U
Mt12tx_Mp_f31 t12tx/DP t12tx/GP VDDIO VDDIO pfet L=0.13U W=1U
Mt12tx_Mp_f32 t12tx/DP t12tx/GP VDDIO VDDIO pfet L=0.13U W=1U
Mt12tx_Mp_f33 t12tx/DP t12tx/GP VDDIO VDDIO pfet L=0.13U W=1U
Mt12tx_Mp_f34 t12tx/DP t12tx/GP VDDIO VDDIO pfet L=0.13U W=1U
Mt12tx_Mp_f35 t12tx/DP t12tx/GP VDDIO VDDIO pfet L=0.13U W=1U
Mt12tx_Mp_f36 t12tx/DP t12tx/GP VDDIO VDDIO pfet L=0.13U W=1U
Mt12tx_Mp_f37 t12tx/DP t12tx/GP VDDIO VDDIO pfet L=0.13U W=1U
Mt12tx_Mp_f38 t12tx/DP t12tx/GP VDDIO VDDIO pfet L=0.13U W=1U
Mt12tx_Mp_f39 t12tx/DP t12tx/GP VDDIO VDDIO pfet L=0.13U W=1U
Mt12tx_Mp_f40 t12tx/DP t12tx/GP VDDIO VDDIO pfet L=0.13U W=1U
Mt12tx_Mp_f41 t12tx/DP t12tx/GP VDDIO VDDIO pfet L=0.13U W=1U
Mt12tx_Mp_f42 t12tx/DP t12tx/GP VDDIO VDDIO pfet L=0.13U W=1U
Mt12tx_Mp_f43 t12tx/DP t12tx/GP VDDIO VDDIO pfet L=0.13U W=1U
Mt12tx_Mp_f44 t12tx/DP t12tx/GP VDDIO VDDIO pfet L=0.13U W=1U
Mt12tx_Mp_f45 t12tx/DP t12tx/GP VDDIO VDDIO pfet L=0.13U W=1U
Mt12tx_Mp_f46 t12tx/DP t12tx/GP VDDIO VDDIO pfet L=0.13U W=1U
Mt12tx_Mp_f47 t12tx/DP t12tx/GP VDDIO VDDIO pfet L=0.13U W=1U
Mt12tx_Mp_f48 t12tx/DP t12tx/GP VDDIO VDDIO pfet L=0.13U W=1U
Mt12tx_Mp_f49 t12tx/DP t12tx/GP VDDIO VDDIO pfet L=0.13U W=1U
Mt12tx_Mp_f50 t12tx/DP t12tx/GP VDDIO VDDIO pfet L=0.13U W=1U
Mt12tx_Mp_f51 t12tx/DP t12tx/GP VDDIO VDDIO pfet L=0.13U W=1U
Mt12tx_Mp_f52 t12tx/DP t12tx/GP VDDIO VDDIO pfet L=0.13U W=1U
Mt12tx_Mp_f53 t12tx/DP t12tx/GP VDDIO VDDIO pfet L=0.13U W=1U
Mt12tx_Mn_f0 t12tx/DN t12tx/GN VSS VSS nfet L=0.13U W=1U
Mt12tx_Mn_f1 t12tx/DN t12tx/GN VSS VSS nfet L=0.13U W=1U
Mt12tx_Mn_f2 t12tx/DN t12tx/GN VSS VSS nfet L=0.13U W=1U
Mt12tx_Mn_f3 t12tx/DN t12tx/GN VSS VSS nfet L=0.13U W=1U
Mt12tx_Mn_f4 t12tx/DN t12tx/GN VSS VSS nfet L=0.13U W=1U
Mt12tx_Mn_f5 t12tx/DN t12tx/GN VSS VSS nfet L=0.13U W=1U
Mt12tx_Mn_f6 t12tx/DN t12tx/GN VSS VSS nfet L=0.13U W=1U
Mt12tx_Mn_f7 t12tx/DN t12tx/GN VSS VSS nfet L=0.13U W=1U
Mt12tx_Mn_f8 t12tx/DN t12tx/GN VSS VSS nfet L=0.13U W=1U
Mt12tx_Mn_f9 t12tx/DN t12tx/GN VSS VSS nfet L=0.13U W=1U
Mt12tx_Mn_f10 t12tx/DN t12tx/GN VSS VSS nfet L=0.13U W=1U
Mt12tx_Mn_f11 t12tx/DN t12tx/GN VSS VSS nfet L=0.13U W=1U
Mt12tx_Mn_f12 t12tx/DN t12tx/GN VSS VSS nfet L=0.13U W=1U
Mt12tx_Mn_f13 t12tx/DN t12tx/GN VSS VSS nfet L=0.13U W=1U
Mt12tx_Mn_f14 t12tx/DN t12tx/GN VSS VSS nfet L=0.13U W=1U
Mt12tx_Mn_f15 t12tx/DN t12tx/GN VSS VSS nfet L=0.13U W=1U
Mt12tx_Mn_f16 t12tx/DN t12tx/GN VSS VSS nfet L=0.13U W=1U
Mt12tx_Mn_f17 t12tx/DN t12tx/GN VSS VSS nfet L=0.13U W=1U
Mt12tx_Mn_f18 t12tx/DN t12tx/GN VSS VSS nfet L=0.13U W=1U
Mt12tx_Mn_f19 t12tx/DN t12tx/GN VSS VSS nfet L=0.13U W=1U
Mt12tx_Mn_f20 t12tx/DN t12tx/GN VSS VSS nfet L=0.13U W=1U
Mt12tx_Mn_f21 t12tx/DN t12tx/GN VSS VSS nfet L=0.13U W=1U
Mt12tx_Mpu_f0 t12tx/PUX PUN VDDIO VDDIO pfet L=0.13U W=2U
Xt12tx_Rpu t12tx/PUX PAD VSS rppd r=12472.0 L=24U W=0.5U
Mt12tx_Mpd_f0 t12tx/PDX PD VSS VSS nfet L=0.13U W=1U
Xt12tx_Rpd PAD t12tx/PDX VSS rppd r=12472.0 L=24U W=0.5U
Xt12tx_Rsp t12tx/DP PAD VSS rppd r=20.0 L=0.5U W=10U
Xt12tx_Rsn t12tx/DN PAD VSS rppd r=20.0 L=0.5U W=10U
Dt13esd_Dp1 PAD$2 VDDIO diodevdd_mod A=35P P=58.08U
Dt13esd_Dp1_dsub VSS VDDIO dsub_2kv_mod A=224.956P P=81.12U
Mt13esd_Mn1_f0 PAD$2 VSS VSS VSS nfet L=0.13U W=2U
Mt13esd_Mn1_f1 PAD$2 VSS VSS VSS nfet L=0.13U W=2U
Mt13esd_Mn1_f2 PAD$2 VSS VSS VSS nfet L=0.13U W=2U
Mt13esd_Mn1_f3 PAD$2 VSS VSS VSS nfet L=0.13U W=2U
Mt13esd_Mn1_f4 PAD$2 VSS VSS VSS nfet L=0.13U W=2U
Mt13esd_Mn1_f5 PAD$2 VSS VSS VSS nfet L=0.13U W=2U
Mt13esd_Mn1_f6 PAD$2 VSS VSS VSS nfet L=0.13U W=2U
Mt13esd_Mn1_f7 PAD$2 VSS VSS VSS nfet L=0.13U W=2U
Mt13esd_Mn1_f8 PAD$2 VSS VSS VSS nfet L=0.13U W=2U
Mt13esd_Mn1_f9 PAD$2 VSS VSS VSS nfet L=0.13U W=2U
Mt13esd_Mclamp_f0 VDDIO VSS VSS VSS nfet L=0.35U W=2U
Mt13esd_Mclamp_f1 VDDIO VSS VSS VSS nfet L=0.35U W=2U
Mt13esd_Mclamp_f2 VDDIO VSS VSS VSS nfet L=0.35U W=2U
Mt13esd_Mclamp_f3 VDDIO VSS VSS VSS nfet L=0.35U W=2U
Mt13esd_Mclamp_f4 VDDIO VSS VSS VSS nfet L=0.35U W=2U
Mt13esd_Mclamp_f5 VDDIO VSS VSS VSS nfet L=0.35U W=2U
Mt13esd_Mclamp_f6 VDDIO VSS VSS VSS nfet L=0.35U W=2U
Mt13esd_Mclamp_f7 VDDIO VSS VSS VSS nfet L=0.35U W=2U
Mt13esd_Mclamp_f8 VDDIO VSS VSS VSS nfet L=0.35U W=2U
Mt13esd_Mclamp_f9 VDDIO VSS VSS VSS nfet L=0.35U W=2U
Mt13esd_Mclamp_f10 VDDIO VSS VSS VSS nfet L=0.35U W=2U
Mt13esd_Mclamp_f11 VDDIO VSS VSS VSS nfet L=0.35U W=2U
Mt13esd_Mclamp_f12 VDDIO VSS VSS VSS nfet L=0.35U W=2U
Mt13esd_Mclamp_f13 VDDIO VSS VSS VSS nfet L=0.35U W=2U
Mt13esd_Mclamp_f14 VDDIO VSS VSS VSS nfet L=0.35U W=2U
Mt13esd_Mclamp_f15 VDDIO VSS VSS VSS nfet L=0.35U W=2U
Mt13esd_Mclamp_f16 VDDIO VSS VSS VSS nfet L=0.35U W=2U
Mt13esd_Mclamp_f17 VDDIO VSS VSS VSS nfet L=0.35U W=2U
Mt13esd_Mclamp_f18 VDDIO VSS VSS VSS nfet L=0.35U W=2U
Mt13esd_Mclamp_f19 VDDIO VSS VSS VSS nfet L=0.35U W=2U
Xt13esd_Resd PAD$2 PADI_T13 VSS rppd r=164.6 L=1U W=2U
Dt13esd_Dp2 PADI_T13 VDDIO dpantenna A=4P P=8U
Mt13esd_Mn2_f0 PADI_T13 VSS VSS VSS nfet L=0.13U W=1U
Mt13tx_Mi1p_f0 t13tx/OEB OE VDDIO VDDIO pfet L=0.13U W=2U
Mt13tx_Mi1n_f0 t13tx/OEB OE VSS VSS nfet L=0.13U W=1U
Mt13tx_Mnd1p_f0 t13tx/GP DIN$13 VDDIO VDDIO pfet L=0.13U W=2U
Mt13tx_Mnd1p_f1 t13tx/GP DIN$13 VDDIO VDDIO pfet L=0.13U W=2U
Mt13tx_Mnd2p_f0 t13tx/GP OE VDDIO VDDIO pfet L=0.13U W=2U
Mt13tx_Mnd2p_f1 t13tx/GP OE VDDIO VDDIO pfet L=0.13U W=2U
Mt13tx_Mnd1n_f0 t13tx/GP DIN$13 t13tx/NA VSS nfet L=0.13U W=2U
Mt13tx_Mnd1n_f1 t13tx/GP DIN$13 t13tx/NA VSS nfet L=0.13U W=2U
Mt13tx_Mnd2n_f0 t13tx/NA OE VSS VSS nfet L=0.13U W=2U
Mt13tx_Mnd2n_f1 t13tx/NA OE VSS VSS nfet L=0.13U W=2U
Mt13tx_Mnr1p_f0 t13tx/NB DIN$13 VDDIO VDDIO pfet L=0.13U W=2U
Mt13tx_Mnr1p_f1 t13tx/NB DIN$13 VDDIO VDDIO pfet L=0.13U W=2U
Mt13tx_Mnr1p_f2 t13tx/NB DIN$13 VDDIO VDDIO pfet L=0.13U W=2U
Mt13tx_Mnr1p_f3 t13tx/NB DIN$13 VDDIO VDDIO pfet L=0.13U W=2U
Mt13tx_Mnr2p_f0 t13tx/GN t13tx/OEB t13tx/NB VDDIO pfet L=0.13U W=2U
Mt13tx_Mnr2p_f1 t13tx/GN t13tx/OEB t13tx/NB VDDIO pfet L=0.13U W=2U
Mt13tx_Mnr2p_f2 t13tx/GN t13tx/OEB t13tx/NB VDDIO pfet L=0.13U W=2U
Mt13tx_Mnr2p_f3 t13tx/GN t13tx/OEB t13tx/NB VDDIO pfet L=0.13U W=2U
Mt13tx_Mnr1n_f0 t13tx/GN DIN$13 VSS VSS nfet L=0.13U W=1U
Mt13tx_Mnr1n_f1 t13tx/GN DIN$13 VSS VSS nfet L=0.13U W=1U
Mt13tx_Mnr2n_f0 t13tx/GN t13tx/OEB VSS VSS nfet L=0.13U W=1U
Mt13tx_Mnr2n_f1 t13tx/GN t13tx/OEB VSS VSS nfet L=0.13U W=1U
Mt13tx_Mp_f0 t13tx/DP t13tx/GP VDDIO VDDIO pfet L=0.13U W=1U
Mt13tx_Mp_f1 t13tx/DP t13tx/GP VDDIO VDDIO pfet L=0.13U W=1U
Mt13tx_Mp_f2 t13tx/DP t13tx/GP VDDIO VDDIO pfet L=0.13U W=1U
Mt13tx_Mp_f3 t13tx/DP t13tx/GP VDDIO VDDIO pfet L=0.13U W=1U
Mt13tx_Mp_f4 t13tx/DP t13tx/GP VDDIO VDDIO pfet L=0.13U W=1U
Mt13tx_Mp_f5 t13tx/DP t13tx/GP VDDIO VDDIO pfet L=0.13U W=1U
Mt13tx_Mp_f6 t13tx/DP t13tx/GP VDDIO VDDIO pfet L=0.13U W=1U
Mt13tx_Mp_f7 t13tx/DP t13tx/GP VDDIO VDDIO pfet L=0.13U W=1U
Mt13tx_Mp_f8 t13tx/DP t13tx/GP VDDIO VDDIO pfet L=0.13U W=1U
Mt13tx_Mp_f9 t13tx/DP t13tx/GP VDDIO VDDIO pfet L=0.13U W=1U
Mt13tx_Mp_f10 t13tx/DP t13tx/GP VDDIO VDDIO pfet L=0.13U W=1U
Mt13tx_Mp_f11 t13tx/DP t13tx/GP VDDIO VDDIO pfet L=0.13U W=1U
Mt13tx_Mp_f12 t13tx/DP t13tx/GP VDDIO VDDIO pfet L=0.13U W=1U
Mt13tx_Mp_f13 t13tx/DP t13tx/GP VDDIO VDDIO pfet L=0.13U W=1U
Mt13tx_Mp_f14 t13tx/DP t13tx/GP VDDIO VDDIO pfet L=0.13U W=1U
Mt13tx_Mp_f15 t13tx/DP t13tx/GP VDDIO VDDIO pfet L=0.13U W=1U
Mt13tx_Mp_f16 t13tx/DP t13tx/GP VDDIO VDDIO pfet L=0.13U W=1U
Mt13tx_Mp_f17 t13tx/DP t13tx/GP VDDIO VDDIO pfet L=0.13U W=1U
Mt13tx_Mp_f18 t13tx/DP t13tx/GP VDDIO VDDIO pfet L=0.13U W=1U
Mt13tx_Mp_f19 t13tx/DP t13tx/GP VDDIO VDDIO pfet L=0.13U W=1U
Mt13tx_Mp_f20 t13tx/DP t13tx/GP VDDIO VDDIO pfet L=0.13U W=1U
Mt13tx_Mp_f21 t13tx/DP t13tx/GP VDDIO VDDIO pfet L=0.13U W=1U
Mt13tx_Mp_f22 t13tx/DP t13tx/GP VDDIO VDDIO pfet L=0.13U W=1U
Mt13tx_Mp_f23 t13tx/DP t13tx/GP VDDIO VDDIO pfet L=0.13U W=1U
Mt13tx_Mp_f24 t13tx/DP t13tx/GP VDDIO VDDIO pfet L=0.13U W=1U
Mt13tx_Mp_f25 t13tx/DP t13tx/GP VDDIO VDDIO pfet L=0.13U W=1U
Mt13tx_Mp_f26 t13tx/DP t13tx/GP VDDIO VDDIO pfet L=0.13U W=1U
Mt13tx_Mp_f27 t13tx/DP t13tx/GP VDDIO VDDIO pfet L=0.13U W=1U
Mt13tx_Mp_f28 t13tx/DP t13tx/GP VDDIO VDDIO pfet L=0.13U W=1U
Mt13tx_Mp_f29 t13tx/DP t13tx/GP VDDIO VDDIO pfet L=0.13U W=1U
Mt13tx_Mp_f30 t13tx/DP t13tx/GP VDDIO VDDIO pfet L=0.13U W=1U
Mt13tx_Mp_f31 t13tx/DP t13tx/GP VDDIO VDDIO pfet L=0.13U W=1U
Mt13tx_Mp_f32 t13tx/DP t13tx/GP VDDIO VDDIO pfet L=0.13U W=1U
Mt13tx_Mp_f33 t13tx/DP t13tx/GP VDDIO VDDIO pfet L=0.13U W=1U
Mt13tx_Mp_f34 t13tx/DP t13tx/GP VDDIO VDDIO pfet L=0.13U W=1U
Mt13tx_Mp_f35 t13tx/DP t13tx/GP VDDIO VDDIO pfet L=0.13U W=1U
Mt13tx_Mp_f36 t13tx/DP t13tx/GP VDDIO VDDIO pfet L=0.13U W=1U
Mt13tx_Mp_f37 t13tx/DP t13tx/GP VDDIO VDDIO pfet L=0.13U W=1U
Mt13tx_Mp_f38 t13tx/DP t13tx/GP VDDIO VDDIO pfet L=0.13U W=1U
Mt13tx_Mp_f39 t13tx/DP t13tx/GP VDDIO VDDIO pfet L=0.13U W=1U
Mt13tx_Mp_f40 t13tx/DP t13tx/GP VDDIO VDDIO pfet L=0.13U W=1U
Mt13tx_Mp_f41 t13tx/DP t13tx/GP VDDIO VDDIO pfet L=0.13U W=1U
Mt13tx_Mp_f42 t13tx/DP t13tx/GP VDDIO VDDIO pfet L=0.13U W=1U
Mt13tx_Mp_f43 t13tx/DP t13tx/GP VDDIO VDDIO pfet L=0.13U W=1U
Mt13tx_Mp_f44 t13tx/DP t13tx/GP VDDIO VDDIO pfet L=0.13U W=1U
Mt13tx_Mp_f45 t13tx/DP t13tx/GP VDDIO VDDIO pfet L=0.13U W=1U
Mt13tx_Mp_f46 t13tx/DP t13tx/GP VDDIO VDDIO pfet L=0.13U W=1U
Mt13tx_Mp_f47 t13tx/DP t13tx/GP VDDIO VDDIO pfet L=0.13U W=1U
Mt13tx_Mp_f48 t13tx/DP t13tx/GP VDDIO VDDIO pfet L=0.13U W=1U
Mt13tx_Mp_f49 t13tx/DP t13tx/GP VDDIO VDDIO pfet L=0.13U W=1U
Mt13tx_Mp_f50 t13tx/DP t13tx/GP VDDIO VDDIO pfet L=0.13U W=1U
Mt13tx_Mp_f51 t13tx/DP t13tx/GP VDDIO VDDIO pfet L=0.13U W=1U
Mt13tx_Mp_f52 t13tx/DP t13tx/GP VDDIO VDDIO pfet L=0.13U W=1U
Mt13tx_Mp_f53 t13tx/DP t13tx/GP VDDIO VDDIO pfet L=0.13U W=1U
Mt13tx_Mn_f0 t13tx/DN t13tx/GN VSS VSS nfet L=0.13U W=1U
Mt13tx_Mn_f1 t13tx/DN t13tx/GN VSS VSS nfet L=0.13U W=1U
Mt13tx_Mn_f2 t13tx/DN t13tx/GN VSS VSS nfet L=0.13U W=1U
Mt13tx_Mn_f3 t13tx/DN t13tx/GN VSS VSS nfet L=0.13U W=1U
Mt13tx_Mn_f4 t13tx/DN t13tx/GN VSS VSS nfet L=0.13U W=1U
Mt13tx_Mn_f5 t13tx/DN t13tx/GN VSS VSS nfet L=0.13U W=1U
Mt13tx_Mn_f6 t13tx/DN t13tx/GN VSS VSS nfet L=0.13U W=1U
Mt13tx_Mn_f7 t13tx/DN t13tx/GN VSS VSS nfet L=0.13U W=1U
Mt13tx_Mn_f8 t13tx/DN t13tx/GN VSS VSS nfet L=0.13U W=1U
Mt13tx_Mn_f9 t13tx/DN t13tx/GN VSS VSS nfet L=0.13U W=1U
Mt13tx_Mn_f10 t13tx/DN t13tx/GN VSS VSS nfet L=0.13U W=1U
Mt13tx_Mn_f11 t13tx/DN t13tx/GN VSS VSS nfet L=0.13U W=1U
Mt13tx_Mn_f12 t13tx/DN t13tx/GN VSS VSS nfet L=0.13U W=1U
Mt13tx_Mn_f13 t13tx/DN t13tx/GN VSS VSS nfet L=0.13U W=1U
Mt13tx_Mn_f14 t13tx/DN t13tx/GN VSS VSS nfet L=0.13U W=1U
Mt13tx_Mn_f15 t13tx/DN t13tx/GN VSS VSS nfet L=0.13U W=1U
Mt13tx_Mn_f16 t13tx/DN t13tx/GN VSS VSS nfet L=0.13U W=1U
Mt13tx_Mn_f17 t13tx/DN t13tx/GN VSS VSS nfet L=0.13U W=1U
Mt13tx_Mn_f18 t13tx/DN t13tx/GN VSS VSS nfet L=0.13U W=1U
Mt13tx_Mn_f19 t13tx/DN t13tx/GN VSS VSS nfet L=0.13U W=1U
Mt13tx_Mn_f20 t13tx/DN t13tx/GN VSS VSS nfet L=0.13U W=1U
Mt13tx_Mn_f21 t13tx/DN t13tx/GN VSS VSS nfet L=0.13U W=1U
Mt13tx_Mpu_f0 t13tx/PUX PUN VDDIO VDDIO pfet L=0.13U W=2U
Xt13tx_Rpu t13tx/PUX PAD$2 VSS rppd r=12472.0 L=24U W=0.5U
Mt13tx_Mpd_f0 t13tx/PDX PD VSS VSS nfet L=0.13U W=1U
Xt13tx_Rpd PAD$2 t13tx/PDX VSS rppd r=12472.0 L=24U W=0.5U
Xt13tx_Rsp t13tx/DP PAD$2 VSS rppd r=20.0 L=0.5U W=10U
Xt13tx_Rsn t13tx/DN PAD$2 VSS rppd r=20.0 L=0.5U W=10U
Dt14esd_Dp1 PAD$4 VDDIO diodevdd_mod A=35P P=58.08U
Dt14esd_Dp1_dsub VSS VDDIO dsub_2kv_mod A=224.956P P=81.12U
Mt14esd_Mn1_f0 PAD$4 VSS VSS VSS nfet L=0.13U W=2U
Mt14esd_Mn1_f1 PAD$4 VSS VSS VSS nfet L=0.13U W=2U
Mt14esd_Mn1_f2 PAD$4 VSS VSS VSS nfet L=0.13U W=2U
Mt14esd_Mn1_f3 PAD$4 VSS VSS VSS nfet L=0.13U W=2U
Mt14esd_Mn1_f4 PAD$4 VSS VSS VSS nfet L=0.13U W=2U
Mt14esd_Mn1_f5 PAD$4 VSS VSS VSS nfet L=0.13U W=2U
Mt14esd_Mn1_f6 PAD$4 VSS VSS VSS nfet L=0.13U W=2U
Mt14esd_Mn1_f7 PAD$4 VSS VSS VSS nfet L=0.13U W=2U
Mt14esd_Mn1_f8 PAD$4 VSS VSS VSS nfet L=0.13U W=2U
Mt14esd_Mn1_f9 PAD$4 VSS VSS VSS nfet L=0.13U W=2U
Mt14esd_Mclamp_f0 VDDIO VSS VSS VSS nfet L=0.35U W=2U
Mt14esd_Mclamp_f1 VDDIO VSS VSS VSS nfet L=0.35U W=2U
Mt14esd_Mclamp_f2 VDDIO VSS VSS VSS nfet L=0.35U W=2U
Mt14esd_Mclamp_f3 VDDIO VSS VSS VSS nfet L=0.35U W=2U
Mt14esd_Mclamp_f4 VDDIO VSS VSS VSS nfet L=0.35U W=2U
Mt14esd_Mclamp_f5 VDDIO VSS VSS VSS nfet L=0.35U W=2U
Mt14esd_Mclamp_f6 VDDIO VSS VSS VSS nfet L=0.35U W=2U
Mt14esd_Mclamp_f7 VDDIO VSS VSS VSS nfet L=0.35U W=2U
Mt14esd_Mclamp_f8 VDDIO VSS VSS VSS nfet L=0.35U W=2U
Mt14esd_Mclamp_f9 VDDIO VSS VSS VSS nfet L=0.35U W=2U
Mt14esd_Mclamp_f10 VDDIO VSS VSS VSS nfet L=0.35U W=2U
Mt14esd_Mclamp_f11 VDDIO VSS VSS VSS nfet L=0.35U W=2U
Mt14esd_Mclamp_f12 VDDIO VSS VSS VSS nfet L=0.35U W=2U
Mt14esd_Mclamp_f13 VDDIO VSS VSS VSS nfet L=0.35U W=2U
Mt14esd_Mclamp_f14 VDDIO VSS VSS VSS nfet L=0.35U W=2U
Mt14esd_Mclamp_f15 VDDIO VSS VSS VSS nfet L=0.35U W=2U
Mt14esd_Mclamp_f16 VDDIO VSS VSS VSS nfet L=0.35U W=2U
Mt14esd_Mclamp_f17 VDDIO VSS VSS VSS nfet L=0.35U W=2U
Mt14esd_Mclamp_f18 VDDIO VSS VSS VSS nfet L=0.35U W=2U
Mt14esd_Mclamp_f19 VDDIO VSS VSS VSS nfet L=0.35U W=2U
Xt14esd_Resd PAD$4 PADI_T14 VSS rppd r=164.6 L=1U W=2U
Dt14esd_Dp2 PADI_T14 VDDIO dpantenna A=4P P=8U
Mt14esd_Mn2_f0 PADI_T14 VSS VSS VSS nfet L=0.13U W=1U
Mt14tx_Mi1p_f0 t14tx/OEB OE VDDIO VDDIO pfet L=0.13U W=2U
Mt14tx_Mi1n_f0 t14tx/OEB OE VSS VSS nfet L=0.13U W=1U
Mt14tx_Mnd1p_f0 t14tx/GP DIN$14 VDDIO VDDIO pfet L=0.13U W=2U
Mt14tx_Mnd1p_f1 t14tx/GP DIN$14 VDDIO VDDIO pfet L=0.13U W=2U
Mt14tx_Mnd2p_f0 t14tx/GP OE VDDIO VDDIO pfet L=0.13U W=2U
Mt14tx_Mnd2p_f1 t14tx/GP OE VDDIO VDDIO pfet L=0.13U W=2U
Mt14tx_Mnd1n_f0 t14tx/GP DIN$14 t14tx/NA VSS nfet L=0.13U W=2U
Mt14tx_Mnd1n_f1 t14tx/GP DIN$14 t14tx/NA VSS nfet L=0.13U W=2U
Mt14tx_Mnd2n_f0 t14tx/NA OE VSS VSS nfet L=0.13U W=2U
Mt14tx_Mnd2n_f1 t14tx/NA OE VSS VSS nfet L=0.13U W=2U
Mt14tx_Mnr1p_f0 t14tx/NB DIN$14 VDDIO VDDIO pfet L=0.13U W=2U
Mt14tx_Mnr1p_f1 t14tx/NB DIN$14 VDDIO VDDIO pfet L=0.13U W=2U
Mt14tx_Mnr1p_f2 t14tx/NB DIN$14 VDDIO VDDIO pfet L=0.13U W=2U
Mt14tx_Mnr1p_f3 t14tx/NB DIN$14 VDDIO VDDIO pfet L=0.13U W=2U
Mt14tx_Mnr2p_f0 t14tx/GN t14tx/OEB t14tx/NB VDDIO pfet L=0.13U W=2U
Mt14tx_Mnr2p_f1 t14tx/GN t14tx/OEB t14tx/NB VDDIO pfet L=0.13U W=2U
Mt14tx_Mnr2p_f2 t14tx/GN t14tx/OEB t14tx/NB VDDIO pfet L=0.13U W=2U
Mt14tx_Mnr2p_f3 t14tx/GN t14tx/OEB t14tx/NB VDDIO pfet L=0.13U W=2U
Mt14tx_Mnr1n_f0 t14tx/GN DIN$14 VSS VSS nfet L=0.13U W=1U
Mt14tx_Mnr1n_f1 t14tx/GN DIN$14 VSS VSS nfet L=0.13U W=1U
Mt14tx_Mnr2n_f0 t14tx/GN t14tx/OEB VSS VSS nfet L=0.13U W=1U
Mt14tx_Mnr2n_f1 t14tx/GN t14tx/OEB VSS VSS nfet L=0.13U W=1U
Mt14tx_Mp_f0 t14tx/DP t14tx/GP VDDIO VDDIO pfet L=0.13U W=1U
Mt14tx_Mp_f1 t14tx/DP t14tx/GP VDDIO VDDIO pfet L=0.13U W=1U
Mt14tx_Mp_f2 t14tx/DP t14tx/GP VDDIO VDDIO pfet L=0.13U W=1U
Mt14tx_Mp_f3 t14tx/DP t14tx/GP VDDIO VDDIO pfet L=0.13U W=1U
Mt14tx_Mp_f4 t14tx/DP t14tx/GP VDDIO VDDIO pfet L=0.13U W=1U
Mt14tx_Mp_f5 t14tx/DP t14tx/GP VDDIO VDDIO pfet L=0.13U W=1U
Mt14tx_Mp_f6 t14tx/DP t14tx/GP VDDIO VDDIO pfet L=0.13U W=1U
Mt14tx_Mp_f7 t14tx/DP t14tx/GP VDDIO VDDIO pfet L=0.13U W=1U
Mt14tx_Mp_f8 t14tx/DP t14tx/GP VDDIO VDDIO pfet L=0.13U W=1U
Mt14tx_Mp_f9 t14tx/DP t14tx/GP VDDIO VDDIO pfet L=0.13U W=1U
Mt14tx_Mp_f10 t14tx/DP t14tx/GP VDDIO VDDIO pfet L=0.13U W=1U
Mt14tx_Mp_f11 t14tx/DP t14tx/GP VDDIO VDDIO pfet L=0.13U W=1U
Mt14tx_Mp_f12 t14tx/DP t14tx/GP VDDIO VDDIO pfet L=0.13U W=1U
Mt14tx_Mp_f13 t14tx/DP t14tx/GP VDDIO VDDIO pfet L=0.13U W=1U
Mt14tx_Mp_f14 t14tx/DP t14tx/GP VDDIO VDDIO pfet L=0.13U W=1U
Mt14tx_Mp_f15 t14tx/DP t14tx/GP VDDIO VDDIO pfet L=0.13U W=1U
Mt14tx_Mp_f16 t14tx/DP t14tx/GP VDDIO VDDIO pfet L=0.13U W=1U
Mt14tx_Mp_f17 t14tx/DP t14tx/GP VDDIO VDDIO pfet L=0.13U W=1U
Mt14tx_Mp_f18 t14tx/DP t14tx/GP VDDIO VDDIO pfet L=0.13U W=1U
Mt14tx_Mp_f19 t14tx/DP t14tx/GP VDDIO VDDIO pfet L=0.13U W=1U
Mt14tx_Mp_f20 t14tx/DP t14tx/GP VDDIO VDDIO pfet L=0.13U W=1U
Mt14tx_Mp_f21 t14tx/DP t14tx/GP VDDIO VDDIO pfet L=0.13U W=1U
Mt14tx_Mp_f22 t14tx/DP t14tx/GP VDDIO VDDIO pfet L=0.13U W=1U
Mt14tx_Mp_f23 t14tx/DP t14tx/GP VDDIO VDDIO pfet L=0.13U W=1U
Mt14tx_Mp_f24 t14tx/DP t14tx/GP VDDIO VDDIO pfet L=0.13U W=1U
Mt14tx_Mp_f25 t14tx/DP t14tx/GP VDDIO VDDIO pfet L=0.13U W=1U
Mt14tx_Mp_f26 t14tx/DP t14tx/GP VDDIO VDDIO pfet L=0.13U W=1U
Mt14tx_Mp_f27 t14tx/DP t14tx/GP VDDIO VDDIO pfet L=0.13U W=1U
Mt14tx_Mp_f28 t14tx/DP t14tx/GP VDDIO VDDIO pfet L=0.13U W=1U
Mt14tx_Mp_f29 t14tx/DP t14tx/GP VDDIO VDDIO pfet L=0.13U W=1U
Mt14tx_Mp_f30 t14tx/DP t14tx/GP VDDIO VDDIO pfet L=0.13U W=1U
Mt14tx_Mp_f31 t14tx/DP t14tx/GP VDDIO VDDIO pfet L=0.13U W=1U
Mt14tx_Mp_f32 t14tx/DP t14tx/GP VDDIO VDDIO pfet L=0.13U W=1U
Mt14tx_Mp_f33 t14tx/DP t14tx/GP VDDIO VDDIO pfet L=0.13U W=1U
Mt14tx_Mp_f34 t14tx/DP t14tx/GP VDDIO VDDIO pfet L=0.13U W=1U
Mt14tx_Mp_f35 t14tx/DP t14tx/GP VDDIO VDDIO pfet L=0.13U W=1U
Mt14tx_Mp_f36 t14tx/DP t14tx/GP VDDIO VDDIO pfet L=0.13U W=1U
Mt14tx_Mp_f37 t14tx/DP t14tx/GP VDDIO VDDIO pfet L=0.13U W=1U
Mt14tx_Mp_f38 t14tx/DP t14tx/GP VDDIO VDDIO pfet L=0.13U W=1U
Mt14tx_Mp_f39 t14tx/DP t14tx/GP VDDIO VDDIO pfet L=0.13U W=1U
Mt14tx_Mp_f40 t14tx/DP t14tx/GP VDDIO VDDIO pfet L=0.13U W=1U
Mt14tx_Mp_f41 t14tx/DP t14tx/GP VDDIO VDDIO pfet L=0.13U W=1U
Mt14tx_Mp_f42 t14tx/DP t14tx/GP VDDIO VDDIO pfet L=0.13U W=1U
Mt14tx_Mp_f43 t14tx/DP t14tx/GP VDDIO VDDIO pfet L=0.13U W=1U
Mt14tx_Mp_f44 t14tx/DP t14tx/GP VDDIO VDDIO pfet L=0.13U W=1U
Mt14tx_Mp_f45 t14tx/DP t14tx/GP VDDIO VDDIO pfet L=0.13U W=1U
Mt14tx_Mp_f46 t14tx/DP t14tx/GP VDDIO VDDIO pfet L=0.13U W=1U
Mt14tx_Mp_f47 t14tx/DP t14tx/GP VDDIO VDDIO pfet L=0.13U W=1U
Mt14tx_Mp_f48 t14tx/DP t14tx/GP VDDIO VDDIO pfet L=0.13U W=1U
Mt14tx_Mp_f49 t14tx/DP t14tx/GP VDDIO VDDIO pfet L=0.13U W=1U
Mt14tx_Mp_f50 t14tx/DP t14tx/GP VDDIO VDDIO pfet L=0.13U W=1U
Mt14tx_Mp_f51 t14tx/DP t14tx/GP VDDIO VDDIO pfet L=0.13U W=1U
Mt14tx_Mp_f52 t14tx/DP t14tx/GP VDDIO VDDIO pfet L=0.13U W=1U
Mt14tx_Mp_f53 t14tx/DP t14tx/GP VDDIO VDDIO pfet L=0.13U W=1U
Mt14tx_Mn_f0 t14tx/DN t14tx/GN VSS VSS nfet L=0.13U W=1U
Mt14tx_Mn_f1 t14tx/DN t14tx/GN VSS VSS nfet L=0.13U W=1U
Mt14tx_Mn_f2 t14tx/DN t14tx/GN VSS VSS nfet L=0.13U W=1U
Mt14tx_Mn_f3 t14tx/DN t14tx/GN VSS VSS nfet L=0.13U W=1U
Mt14tx_Mn_f4 t14tx/DN t14tx/GN VSS VSS nfet L=0.13U W=1U
Mt14tx_Mn_f5 t14tx/DN t14tx/GN VSS VSS nfet L=0.13U W=1U
Mt14tx_Mn_f6 t14tx/DN t14tx/GN VSS VSS nfet L=0.13U W=1U
Mt14tx_Mn_f7 t14tx/DN t14tx/GN VSS VSS nfet L=0.13U W=1U
Mt14tx_Mn_f8 t14tx/DN t14tx/GN VSS VSS nfet L=0.13U W=1U
Mt14tx_Mn_f9 t14tx/DN t14tx/GN VSS VSS nfet L=0.13U W=1U
Mt14tx_Mn_f10 t14tx/DN t14tx/GN VSS VSS nfet L=0.13U W=1U
Mt14tx_Mn_f11 t14tx/DN t14tx/GN VSS VSS nfet L=0.13U W=1U
Mt14tx_Mn_f12 t14tx/DN t14tx/GN VSS VSS nfet L=0.13U W=1U
Mt14tx_Mn_f13 t14tx/DN t14tx/GN VSS VSS nfet L=0.13U W=1U
Mt14tx_Mn_f14 t14tx/DN t14tx/GN VSS VSS nfet L=0.13U W=1U
Mt14tx_Mn_f15 t14tx/DN t14tx/GN VSS VSS nfet L=0.13U W=1U
Mt14tx_Mn_f16 t14tx/DN t14tx/GN VSS VSS nfet L=0.13U W=1U
Mt14tx_Mn_f17 t14tx/DN t14tx/GN VSS VSS nfet L=0.13U W=1U
Mt14tx_Mn_f18 t14tx/DN t14tx/GN VSS VSS nfet L=0.13U W=1U
Mt14tx_Mn_f19 t14tx/DN t14tx/GN VSS VSS nfet L=0.13U W=1U
Mt14tx_Mn_f20 t14tx/DN t14tx/GN VSS VSS nfet L=0.13U W=1U
Mt14tx_Mn_f21 t14tx/DN t14tx/GN VSS VSS nfet L=0.13U W=1U
Mt14tx_Mpu_f0 t14tx/PUX PUN VDDIO VDDIO pfet L=0.13U W=2U
Xt14tx_Rpu t14tx/PUX PAD$4 VSS rppd r=12472.0 L=24U W=0.5U
Mt14tx_Mpd_f0 t14tx/PDX PD VSS VSS nfet L=0.13U W=1U
Xt14tx_Rpd PAD$4 t14tx/PDX VSS rppd r=12472.0 L=24U W=0.5U
Xt14tx_Rsp t14tx/DP PAD$4 VSS rppd r=20.0 L=0.5U W=10U
Xt14tx_Rsn t14tx/DN PAD$4 VSS rppd r=20.0 L=0.5U W=10U
Dt15esd_Dp1 PAD$6 VDDIO diodevdd_mod A=35P P=58.08U
Dt15esd_Dp1_dsub VSS VDDIO dsub_2kv_mod A=224.956P P=81.12U
Mt15esd_Mn1_f0 PAD$6 VSS VSS VSS nfet L=0.13U W=2U
Mt15esd_Mn1_f1 PAD$6 VSS VSS VSS nfet L=0.13U W=2U
Mt15esd_Mn1_f2 PAD$6 VSS VSS VSS nfet L=0.13U W=2U
Mt15esd_Mn1_f3 PAD$6 VSS VSS VSS nfet L=0.13U W=2U
Mt15esd_Mn1_f4 PAD$6 VSS VSS VSS nfet L=0.13U W=2U
Mt15esd_Mn1_f5 PAD$6 VSS VSS VSS nfet L=0.13U W=2U
Mt15esd_Mn1_f6 PAD$6 VSS VSS VSS nfet L=0.13U W=2U
Mt15esd_Mn1_f7 PAD$6 VSS VSS VSS nfet L=0.13U W=2U
Mt15esd_Mn1_f8 PAD$6 VSS VSS VSS nfet L=0.13U W=2U
Mt15esd_Mn1_f9 PAD$6 VSS VSS VSS nfet L=0.13U W=2U
Mt15esd_Mclamp_f0 VDDIO VSS VSS VSS nfet L=0.35U W=2U
Mt15esd_Mclamp_f1 VDDIO VSS VSS VSS nfet L=0.35U W=2U
Mt15esd_Mclamp_f2 VDDIO VSS VSS VSS nfet L=0.35U W=2U
Mt15esd_Mclamp_f3 VDDIO VSS VSS VSS nfet L=0.35U W=2U
Mt15esd_Mclamp_f4 VDDIO VSS VSS VSS nfet L=0.35U W=2U
Mt15esd_Mclamp_f5 VDDIO VSS VSS VSS nfet L=0.35U W=2U
Mt15esd_Mclamp_f6 VDDIO VSS VSS VSS nfet L=0.35U W=2U
Mt15esd_Mclamp_f7 VDDIO VSS VSS VSS nfet L=0.35U W=2U
Mt15esd_Mclamp_f8 VDDIO VSS VSS VSS nfet L=0.35U W=2U
Mt15esd_Mclamp_f9 VDDIO VSS VSS VSS nfet L=0.35U W=2U
Mt15esd_Mclamp_f10 VDDIO VSS VSS VSS nfet L=0.35U W=2U
Mt15esd_Mclamp_f11 VDDIO VSS VSS VSS nfet L=0.35U W=2U
Mt15esd_Mclamp_f12 VDDIO VSS VSS VSS nfet L=0.35U W=2U
Mt15esd_Mclamp_f13 VDDIO VSS VSS VSS nfet L=0.35U W=2U
Mt15esd_Mclamp_f14 VDDIO VSS VSS VSS nfet L=0.35U W=2U
Mt15esd_Mclamp_f15 VDDIO VSS VSS VSS nfet L=0.35U W=2U
Mt15esd_Mclamp_f16 VDDIO VSS VSS VSS nfet L=0.35U W=2U
Mt15esd_Mclamp_f17 VDDIO VSS VSS VSS nfet L=0.35U W=2U
Mt15esd_Mclamp_f18 VDDIO VSS VSS VSS nfet L=0.35U W=2U
Mt15esd_Mclamp_f19 VDDIO VSS VSS VSS nfet L=0.35U W=2U
Xt15esd_Resd PAD$6 PADI_T15 VSS rppd r=164.6 L=1U W=2U
Dt15esd_Dp2 PADI_T15 VDDIO dpantenna A=4P P=8U
Mt15esd_Mn2_f0 PADI_T15 VSS VSS VSS nfet L=0.13U W=1U
Mt15tx_Mi1p_f0 t15tx/OEB OE VDDIO VDDIO pfet L=0.13U W=2U
Mt15tx_Mi1n_f0 t15tx/OEB OE VSS VSS nfet L=0.13U W=1U
Mt15tx_Mnd1p_f0 t15tx/GP DIN$15 VDDIO VDDIO pfet L=0.13U W=2U
Mt15tx_Mnd1p_f1 t15tx/GP DIN$15 VDDIO VDDIO pfet L=0.13U W=2U
Mt15tx_Mnd2p_f0 t15tx/GP OE VDDIO VDDIO pfet L=0.13U W=2U
Mt15tx_Mnd2p_f1 t15tx/GP OE VDDIO VDDIO pfet L=0.13U W=2U
Mt15tx_Mnd1n_f0 t15tx/GP DIN$15 t15tx/NA VSS nfet L=0.13U W=2U
Mt15tx_Mnd1n_f1 t15tx/GP DIN$15 t15tx/NA VSS nfet L=0.13U W=2U
Mt15tx_Mnd2n_f0 t15tx/NA OE VSS VSS nfet L=0.13U W=2U
Mt15tx_Mnd2n_f1 t15tx/NA OE VSS VSS nfet L=0.13U W=2U
Mt15tx_Mnr1p_f0 t15tx/NB DIN$15 VDDIO VDDIO pfet L=0.13U W=2U
Mt15tx_Mnr1p_f1 t15tx/NB DIN$15 VDDIO VDDIO pfet L=0.13U W=2U
Mt15tx_Mnr1p_f2 t15tx/NB DIN$15 VDDIO VDDIO pfet L=0.13U W=2U
Mt15tx_Mnr1p_f3 t15tx/NB DIN$15 VDDIO VDDIO pfet L=0.13U W=2U
Mt15tx_Mnr2p_f0 t15tx/GN t15tx/OEB t15tx/NB VDDIO pfet L=0.13U W=2U
Mt15tx_Mnr2p_f1 t15tx/GN t15tx/OEB t15tx/NB VDDIO pfet L=0.13U W=2U
Mt15tx_Mnr2p_f2 t15tx/GN t15tx/OEB t15tx/NB VDDIO pfet L=0.13U W=2U
Mt15tx_Mnr2p_f3 t15tx/GN t15tx/OEB t15tx/NB VDDIO pfet L=0.13U W=2U
Mt15tx_Mnr1n_f0 t15tx/GN DIN$15 VSS VSS nfet L=0.13U W=1U
Mt15tx_Mnr1n_f1 t15tx/GN DIN$15 VSS VSS nfet L=0.13U W=1U
Mt15tx_Mnr2n_f0 t15tx/GN t15tx/OEB VSS VSS nfet L=0.13U W=1U
Mt15tx_Mnr2n_f1 t15tx/GN t15tx/OEB VSS VSS nfet L=0.13U W=1U
Mt15tx_Mp_f0 t15tx/DP t15tx/GP VDDIO VDDIO pfet L=0.13U W=1U
Mt15tx_Mp_f1 t15tx/DP t15tx/GP VDDIO VDDIO pfet L=0.13U W=1U
Mt15tx_Mp_f2 t15tx/DP t15tx/GP VDDIO VDDIO pfet L=0.13U W=1U
Mt15tx_Mp_f3 t15tx/DP t15tx/GP VDDIO VDDIO pfet L=0.13U W=1U
Mt15tx_Mp_f4 t15tx/DP t15tx/GP VDDIO VDDIO pfet L=0.13U W=1U
Mt15tx_Mp_f5 t15tx/DP t15tx/GP VDDIO VDDIO pfet L=0.13U W=1U
Mt15tx_Mp_f6 t15tx/DP t15tx/GP VDDIO VDDIO pfet L=0.13U W=1U
Mt15tx_Mp_f7 t15tx/DP t15tx/GP VDDIO VDDIO pfet L=0.13U W=1U
Mt15tx_Mp_f8 t15tx/DP t15tx/GP VDDIO VDDIO pfet L=0.13U W=1U
Mt15tx_Mp_f9 t15tx/DP t15tx/GP VDDIO VDDIO pfet L=0.13U W=1U
Mt15tx_Mp_f10 t15tx/DP t15tx/GP VDDIO VDDIO pfet L=0.13U W=1U
Mt15tx_Mp_f11 t15tx/DP t15tx/GP VDDIO VDDIO pfet L=0.13U W=1U
Mt15tx_Mp_f12 t15tx/DP t15tx/GP VDDIO VDDIO pfet L=0.13U W=1U
Mt15tx_Mp_f13 t15tx/DP t15tx/GP VDDIO VDDIO pfet L=0.13U W=1U
Mt15tx_Mp_f14 t15tx/DP t15tx/GP VDDIO VDDIO pfet L=0.13U W=1U
Mt15tx_Mp_f15 t15tx/DP t15tx/GP VDDIO VDDIO pfet L=0.13U W=1U
Mt15tx_Mp_f16 t15tx/DP t15tx/GP VDDIO VDDIO pfet L=0.13U W=1U
Mt15tx_Mp_f17 t15tx/DP t15tx/GP VDDIO VDDIO pfet L=0.13U W=1U
Mt15tx_Mp_f18 t15tx/DP t15tx/GP VDDIO VDDIO pfet L=0.13U W=1U
Mt15tx_Mp_f19 t15tx/DP t15tx/GP VDDIO VDDIO pfet L=0.13U W=1U
Mt15tx_Mp_f20 t15tx/DP t15tx/GP VDDIO VDDIO pfet L=0.13U W=1U
Mt15tx_Mp_f21 t15tx/DP t15tx/GP VDDIO VDDIO pfet L=0.13U W=1U
Mt15tx_Mp_f22 t15tx/DP t15tx/GP VDDIO VDDIO pfet L=0.13U W=1U
Mt15tx_Mp_f23 t15tx/DP t15tx/GP VDDIO VDDIO pfet L=0.13U W=1U
Mt15tx_Mp_f24 t15tx/DP t15tx/GP VDDIO VDDIO pfet L=0.13U W=1U
Mt15tx_Mp_f25 t15tx/DP t15tx/GP VDDIO VDDIO pfet L=0.13U W=1U
Mt15tx_Mp_f26 t15tx/DP t15tx/GP VDDIO VDDIO pfet L=0.13U W=1U
Mt15tx_Mp_f27 t15tx/DP t15tx/GP VDDIO VDDIO pfet L=0.13U W=1U
Mt15tx_Mp_f28 t15tx/DP t15tx/GP VDDIO VDDIO pfet L=0.13U W=1U
Mt15tx_Mp_f29 t15tx/DP t15tx/GP VDDIO VDDIO pfet L=0.13U W=1U
Mt15tx_Mp_f30 t15tx/DP t15tx/GP VDDIO VDDIO pfet L=0.13U W=1U
Mt15tx_Mp_f31 t15tx/DP t15tx/GP VDDIO VDDIO pfet L=0.13U W=1U
Mt15tx_Mp_f32 t15tx/DP t15tx/GP VDDIO VDDIO pfet L=0.13U W=1U
Mt15tx_Mp_f33 t15tx/DP t15tx/GP VDDIO VDDIO pfet L=0.13U W=1U
Mt15tx_Mp_f34 t15tx/DP t15tx/GP VDDIO VDDIO pfet L=0.13U W=1U
Mt15tx_Mp_f35 t15tx/DP t15tx/GP VDDIO VDDIO pfet L=0.13U W=1U
Mt15tx_Mp_f36 t15tx/DP t15tx/GP VDDIO VDDIO pfet L=0.13U W=1U
Mt15tx_Mp_f37 t15tx/DP t15tx/GP VDDIO VDDIO pfet L=0.13U W=1U
Mt15tx_Mp_f38 t15tx/DP t15tx/GP VDDIO VDDIO pfet L=0.13U W=1U
Mt15tx_Mp_f39 t15tx/DP t15tx/GP VDDIO VDDIO pfet L=0.13U W=1U
Mt15tx_Mp_f40 t15tx/DP t15tx/GP VDDIO VDDIO pfet L=0.13U W=1U
Mt15tx_Mp_f41 t15tx/DP t15tx/GP VDDIO VDDIO pfet L=0.13U W=1U
Mt15tx_Mp_f42 t15tx/DP t15tx/GP VDDIO VDDIO pfet L=0.13U W=1U
Mt15tx_Mp_f43 t15tx/DP t15tx/GP VDDIO VDDIO pfet L=0.13U W=1U
Mt15tx_Mp_f44 t15tx/DP t15tx/GP VDDIO VDDIO pfet L=0.13U W=1U
Mt15tx_Mp_f45 t15tx/DP t15tx/GP VDDIO VDDIO pfet L=0.13U W=1U
Mt15tx_Mp_f46 t15tx/DP t15tx/GP VDDIO VDDIO pfet L=0.13U W=1U
Mt15tx_Mp_f47 t15tx/DP t15tx/GP VDDIO VDDIO pfet L=0.13U W=1U
Mt15tx_Mp_f48 t15tx/DP t15tx/GP VDDIO VDDIO pfet L=0.13U W=1U
Mt15tx_Mp_f49 t15tx/DP t15tx/GP VDDIO VDDIO pfet L=0.13U W=1U
Mt15tx_Mp_f50 t15tx/DP t15tx/GP VDDIO VDDIO pfet L=0.13U W=1U
Mt15tx_Mp_f51 t15tx/DP t15tx/GP VDDIO VDDIO pfet L=0.13U W=1U
Mt15tx_Mp_f52 t15tx/DP t15tx/GP VDDIO VDDIO pfet L=0.13U W=1U
Mt15tx_Mp_f53 t15tx/DP t15tx/GP VDDIO VDDIO pfet L=0.13U W=1U
Mt15tx_Mn_f0 t15tx/DN t15tx/GN VSS VSS nfet L=0.13U W=1U
Mt15tx_Mn_f1 t15tx/DN t15tx/GN VSS VSS nfet L=0.13U W=1U
Mt15tx_Mn_f2 t15tx/DN t15tx/GN VSS VSS nfet L=0.13U W=1U
Mt15tx_Mn_f3 t15tx/DN t15tx/GN VSS VSS nfet L=0.13U W=1U
Mt15tx_Mn_f4 t15tx/DN t15tx/GN VSS VSS nfet L=0.13U W=1U
Mt15tx_Mn_f5 t15tx/DN t15tx/GN VSS VSS nfet L=0.13U W=1U
Mt15tx_Mn_f6 t15tx/DN t15tx/GN VSS VSS nfet L=0.13U W=1U
Mt15tx_Mn_f7 t15tx/DN t15tx/GN VSS VSS nfet L=0.13U W=1U
Mt15tx_Mn_f8 t15tx/DN t15tx/GN VSS VSS nfet L=0.13U W=1U
Mt15tx_Mn_f9 t15tx/DN t15tx/GN VSS VSS nfet L=0.13U W=1U
Mt15tx_Mn_f10 t15tx/DN t15tx/GN VSS VSS nfet L=0.13U W=1U
Mt15tx_Mn_f11 t15tx/DN t15tx/GN VSS VSS nfet L=0.13U W=1U
Mt15tx_Mn_f12 t15tx/DN t15tx/GN VSS VSS nfet L=0.13U W=1U
Mt15tx_Mn_f13 t15tx/DN t15tx/GN VSS VSS nfet L=0.13U W=1U
Mt15tx_Mn_f14 t15tx/DN t15tx/GN VSS VSS nfet L=0.13U W=1U
Mt15tx_Mn_f15 t15tx/DN t15tx/GN VSS VSS nfet L=0.13U W=1U
Mt15tx_Mn_f16 t15tx/DN t15tx/GN VSS VSS nfet L=0.13U W=1U
Mt15tx_Mn_f17 t15tx/DN t15tx/GN VSS VSS nfet L=0.13U W=1U
Mt15tx_Mn_f18 t15tx/DN t15tx/GN VSS VSS nfet L=0.13U W=1U
Mt15tx_Mn_f19 t15tx/DN t15tx/GN VSS VSS nfet L=0.13U W=1U
Mt15tx_Mn_f20 t15tx/DN t15tx/GN VSS VSS nfet L=0.13U W=1U
Mt15tx_Mn_f21 t15tx/DN t15tx/GN VSS VSS nfet L=0.13U W=1U
Mt15tx_Mpu_f0 t15tx/PUX PUN VDDIO VDDIO pfet L=0.13U W=2U
Xt15tx_Rpu t15tx/PUX PAD$6 VSS rppd r=12472.0 L=24U W=0.5U
Mt15tx_Mpd_f0 t15tx/PDX PD VSS VSS nfet L=0.13U W=1U
Xt15tx_Rpd PAD$6 t15tx/PDX VSS rppd r=12472.0 L=24U W=0.5U
Xt15tx_Rsp t15tx/DP PAD$6 VSS rppd r=20.0 L=0.5U W=10U
Xt15tx_Rsn t15tx/DN PAD$6 VSS rppd r=20.0 L=0.5U W=10U
Dt16esd_Dp1 PAD$8 VDDIO diodevdd_mod A=35P P=58.08U
Dt16esd_Dp1_dsub VSS VDDIO dsub_2kv_mod A=224.956P P=81.12U
Mt16esd_Mn1_f0 PAD$8 VSS VSS VSS nfet L=0.13U W=2U
Mt16esd_Mn1_f1 PAD$8 VSS VSS VSS nfet L=0.13U W=2U
Mt16esd_Mn1_f2 PAD$8 VSS VSS VSS nfet L=0.13U W=2U
Mt16esd_Mn1_f3 PAD$8 VSS VSS VSS nfet L=0.13U W=2U
Mt16esd_Mn1_f4 PAD$8 VSS VSS VSS nfet L=0.13U W=2U
Mt16esd_Mn1_f5 PAD$8 VSS VSS VSS nfet L=0.13U W=2U
Mt16esd_Mn1_f6 PAD$8 VSS VSS VSS nfet L=0.13U W=2U
Mt16esd_Mn1_f7 PAD$8 VSS VSS VSS nfet L=0.13U W=2U
Mt16esd_Mn1_f8 PAD$8 VSS VSS VSS nfet L=0.13U W=2U
Mt16esd_Mn1_f9 PAD$8 VSS VSS VSS nfet L=0.13U W=2U
Mt16esd_Mclamp_f0 VDDIO VSS VSS VSS nfet L=0.35U W=2U
Mt16esd_Mclamp_f1 VDDIO VSS VSS VSS nfet L=0.35U W=2U
Mt16esd_Mclamp_f2 VDDIO VSS VSS VSS nfet L=0.35U W=2U
Mt16esd_Mclamp_f3 VDDIO VSS VSS VSS nfet L=0.35U W=2U
Mt16esd_Mclamp_f4 VDDIO VSS VSS VSS nfet L=0.35U W=2U
Mt16esd_Mclamp_f5 VDDIO VSS VSS VSS nfet L=0.35U W=2U
Mt16esd_Mclamp_f6 VDDIO VSS VSS VSS nfet L=0.35U W=2U
Mt16esd_Mclamp_f7 VDDIO VSS VSS VSS nfet L=0.35U W=2U
Mt16esd_Mclamp_f8 VDDIO VSS VSS VSS nfet L=0.35U W=2U
Mt16esd_Mclamp_f9 VDDIO VSS VSS VSS nfet L=0.35U W=2U
Mt16esd_Mclamp_f10 VDDIO VSS VSS VSS nfet L=0.35U W=2U
Mt16esd_Mclamp_f11 VDDIO VSS VSS VSS nfet L=0.35U W=2U
Mt16esd_Mclamp_f12 VDDIO VSS VSS VSS nfet L=0.35U W=2U
Mt16esd_Mclamp_f13 VDDIO VSS VSS VSS nfet L=0.35U W=2U
Mt16esd_Mclamp_f14 VDDIO VSS VSS VSS nfet L=0.35U W=2U
Mt16esd_Mclamp_f15 VDDIO VSS VSS VSS nfet L=0.35U W=2U
Mt16esd_Mclamp_f16 VDDIO VSS VSS VSS nfet L=0.35U W=2U
Mt16esd_Mclamp_f17 VDDIO VSS VSS VSS nfet L=0.35U W=2U
Mt16esd_Mclamp_f18 VDDIO VSS VSS VSS nfet L=0.35U W=2U
Mt16esd_Mclamp_f19 VDDIO VSS VSS VSS nfet L=0.35U W=2U
Xt16esd_Resd PAD$8 PADI_T16 VSS rppd r=164.6 L=1U W=2U
Dt16esd_Dp2 PADI_T16 VDDIO dpantenna A=4P P=8U
Mt16esd_Mn2_f0 PADI_T16 VSS VSS VSS nfet L=0.13U W=1U
Mt16tx_Mi1p_f0 t16tx/OEB OE VDDIO VDDIO pfet L=0.13U W=2U
Mt16tx_Mi1n_f0 t16tx/OEB OE VSS VSS nfet L=0.13U W=1U
Mt16tx_Mnd1p_f0 t16tx/GP DIN$16 VDDIO VDDIO pfet L=0.13U W=2U
Mt16tx_Mnd1p_f1 t16tx/GP DIN$16 VDDIO VDDIO pfet L=0.13U W=2U
Mt16tx_Mnd2p_f0 t16tx/GP OE VDDIO VDDIO pfet L=0.13U W=2U
Mt16tx_Mnd2p_f1 t16tx/GP OE VDDIO VDDIO pfet L=0.13U W=2U
Mt16tx_Mnd1n_f0 t16tx/GP DIN$16 t16tx/NA VSS nfet L=0.13U W=2U
Mt16tx_Mnd1n_f1 t16tx/GP DIN$16 t16tx/NA VSS nfet L=0.13U W=2U
Mt16tx_Mnd2n_f0 t16tx/NA OE VSS VSS nfet L=0.13U W=2U
Mt16tx_Mnd2n_f1 t16tx/NA OE VSS VSS nfet L=0.13U W=2U
Mt16tx_Mnr1p_f0 t16tx/NB DIN$16 VDDIO VDDIO pfet L=0.13U W=2U
Mt16tx_Mnr1p_f1 t16tx/NB DIN$16 VDDIO VDDIO pfet L=0.13U W=2U
Mt16tx_Mnr1p_f2 t16tx/NB DIN$16 VDDIO VDDIO pfet L=0.13U W=2U
Mt16tx_Mnr1p_f3 t16tx/NB DIN$16 VDDIO VDDIO pfet L=0.13U W=2U
Mt16tx_Mnr2p_f0 t16tx/GN t16tx/OEB t16tx/NB VDDIO pfet L=0.13U W=2U
Mt16tx_Mnr2p_f1 t16tx/GN t16tx/OEB t16tx/NB VDDIO pfet L=0.13U W=2U
Mt16tx_Mnr2p_f2 t16tx/GN t16tx/OEB t16tx/NB VDDIO pfet L=0.13U W=2U
Mt16tx_Mnr2p_f3 t16tx/GN t16tx/OEB t16tx/NB VDDIO pfet L=0.13U W=2U
Mt16tx_Mnr1n_f0 t16tx/GN DIN$16 VSS VSS nfet L=0.13U W=1U
Mt16tx_Mnr1n_f1 t16tx/GN DIN$16 VSS VSS nfet L=0.13U W=1U
Mt16tx_Mnr2n_f0 t16tx/GN t16tx/OEB VSS VSS nfet L=0.13U W=1U
Mt16tx_Mnr2n_f1 t16tx/GN t16tx/OEB VSS VSS nfet L=0.13U W=1U
Mt16tx_Mp_f0 t16tx/DP t16tx/GP VDDIO VDDIO pfet L=0.13U W=1U
Mt16tx_Mp_f1 t16tx/DP t16tx/GP VDDIO VDDIO pfet L=0.13U W=1U
Mt16tx_Mp_f2 t16tx/DP t16tx/GP VDDIO VDDIO pfet L=0.13U W=1U
Mt16tx_Mp_f3 t16tx/DP t16tx/GP VDDIO VDDIO pfet L=0.13U W=1U
Mt16tx_Mp_f4 t16tx/DP t16tx/GP VDDIO VDDIO pfet L=0.13U W=1U
Mt16tx_Mp_f5 t16tx/DP t16tx/GP VDDIO VDDIO pfet L=0.13U W=1U
Mt16tx_Mp_f6 t16tx/DP t16tx/GP VDDIO VDDIO pfet L=0.13U W=1U
Mt16tx_Mp_f7 t16tx/DP t16tx/GP VDDIO VDDIO pfet L=0.13U W=1U
Mt16tx_Mp_f8 t16tx/DP t16tx/GP VDDIO VDDIO pfet L=0.13U W=1U
Mt16tx_Mp_f9 t16tx/DP t16tx/GP VDDIO VDDIO pfet L=0.13U W=1U
Mt16tx_Mp_f10 t16tx/DP t16tx/GP VDDIO VDDIO pfet L=0.13U W=1U
Mt16tx_Mp_f11 t16tx/DP t16tx/GP VDDIO VDDIO pfet L=0.13U W=1U
Mt16tx_Mp_f12 t16tx/DP t16tx/GP VDDIO VDDIO pfet L=0.13U W=1U
Mt16tx_Mp_f13 t16tx/DP t16tx/GP VDDIO VDDIO pfet L=0.13U W=1U
Mt16tx_Mp_f14 t16tx/DP t16tx/GP VDDIO VDDIO pfet L=0.13U W=1U
Mt16tx_Mp_f15 t16tx/DP t16tx/GP VDDIO VDDIO pfet L=0.13U W=1U
Mt16tx_Mp_f16 t16tx/DP t16tx/GP VDDIO VDDIO pfet L=0.13U W=1U
Mt16tx_Mp_f17 t16tx/DP t16tx/GP VDDIO VDDIO pfet L=0.13U W=1U
Mt16tx_Mp_f18 t16tx/DP t16tx/GP VDDIO VDDIO pfet L=0.13U W=1U
Mt16tx_Mp_f19 t16tx/DP t16tx/GP VDDIO VDDIO pfet L=0.13U W=1U
Mt16tx_Mp_f20 t16tx/DP t16tx/GP VDDIO VDDIO pfet L=0.13U W=1U
Mt16tx_Mp_f21 t16tx/DP t16tx/GP VDDIO VDDIO pfet L=0.13U W=1U
Mt16tx_Mp_f22 t16tx/DP t16tx/GP VDDIO VDDIO pfet L=0.13U W=1U
Mt16tx_Mp_f23 t16tx/DP t16tx/GP VDDIO VDDIO pfet L=0.13U W=1U
Mt16tx_Mp_f24 t16tx/DP t16tx/GP VDDIO VDDIO pfet L=0.13U W=1U
Mt16tx_Mp_f25 t16tx/DP t16tx/GP VDDIO VDDIO pfet L=0.13U W=1U
Mt16tx_Mp_f26 t16tx/DP t16tx/GP VDDIO VDDIO pfet L=0.13U W=1U
Mt16tx_Mp_f27 t16tx/DP t16tx/GP VDDIO VDDIO pfet L=0.13U W=1U
Mt16tx_Mp_f28 t16tx/DP t16tx/GP VDDIO VDDIO pfet L=0.13U W=1U
Mt16tx_Mp_f29 t16tx/DP t16tx/GP VDDIO VDDIO pfet L=0.13U W=1U
Mt16tx_Mp_f30 t16tx/DP t16tx/GP VDDIO VDDIO pfet L=0.13U W=1U
Mt16tx_Mp_f31 t16tx/DP t16tx/GP VDDIO VDDIO pfet L=0.13U W=1U
Mt16tx_Mp_f32 t16tx/DP t16tx/GP VDDIO VDDIO pfet L=0.13U W=1U
Mt16tx_Mp_f33 t16tx/DP t16tx/GP VDDIO VDDIO pfet L=0.13U W=1U
Mt16tx_Mp_f34 t16tx/DP t16tx/GP VDDIO VDDIO pfet L=0.13U W=1U
Mt16tx_Mp_f35 t16tx/DP t16tx/GP VDDIO VDDIO pfet L=0.13U W=1U
Mt16tx_Mp_f36 t16tx/DP t16tx/GP VDDIO VDDIO pfet L=0.13U W=1U
Mt16tx_Mp_f37 t16tx/DP t16tx/GP VDDIO VDDIO pfet L=0.13U W=1U
Mt16tx_Mp_f38 t16tx/DP t16tx/GP VDDIO VDDIO pfet L=0.13U W=1U
Mt16tx_Mp_f39 t16tx/DP t16tx/GP VDDIO VDDIO pfet L=0.13U W=1U
Mt16tx_Mp_f40 t16tx/DP t16tx/GP VDDIO VDDIO pfet L=0.13U W=1U
Mt16tx_Mp_f41 t16tx/DP t16tx/GP VDDIO VDDIO pfet L=0.13U W=1U
Mt16tx_Mp_f42 t16tx/DP t16tx/GP VDDIO VDDIO pfet L=0.13U W=1U
Mt16tx_Mp_f43 t16tx/DP t16tx/GP VDDIO VDDIO pfet L=0.13U W=1U
Mt16tx_Mp_f44 t16tx/DP t16tx/GP VDDIO VDDIO pfet L=0.13U W=1U
Mt16tx_Mp_f45 t16tx/DP t16tx/GP VDDIO VDDIO pfet L=0.13U W=1U
Mt16tx_Mp_f46 t16tx/DP t16tx/GP VDDIO VDDIO pfet L=0.13U W=1U
Mt16tx_Mp_f47 t16tx/DP t16tx/GP VDDIO VDDIO pfet L=0.13U W=1U
Mt16tx_Mp_f48 t16tx/DP t16tx/GP VDDIO VDDIO pfet L=0.13U W=1U
Mt16tx_Mp_f49 t16tx/DP t16tx/GP VDDIO VDDIO pfet L=0.13U W=1U
Mt16tx_Mp_f50 t16tx/DP t16tx/GP VDDIO VDDIO pfet L=0.13U W=1U
Mt16tx_Mp_f51 t16tx/DP t16tx/GP VDDIO VDDIO pfet L=0.13U W=1U
Mt16tx_Mp_f52 t16tx/DP t16tx/GP VDDIO VDDIO pfet L=0.13U W=1U
Mt16tx_Mp_f53 t16tx/DP t16tx/GP VDDIO VDDIO pfet L=0.13U W=1U
Mt16tx_Mn_f0 t16tx/DN t16tx/GN VSS VSS nfet L=0.13U W=1U
Mt16tx_Mn_f1 t16tx/DN t16tx/GN VSS VSS nfet L=0.13U W=1U
Mt16tx_Mn_f2 t16tx/DN t16tx/GN VSS VSS nfet L=0.13U W=1U
Mt16tx_Mn_f3 t16tx/DN t16tx/GN VSS VSS nfet L=0.13U W=1U
Mt16tx_Mn_f4 t16tx/DN t16tx/GN VSS VSS nfet L=0.13U W=1U
Mt16tx_Mn_f5 t16tx/DN t16tx/GN VSS VSS nfet L=0.13U W=1U
Mt16tx_Mn_f6 t16tx/DN t16tx/GN VSS VSS nfet L=0.13U W=1U
Mt16tx_Mn_f7 t16tx/DN t16tx/GN VSS VSS nfet L=0.13U W=1U
Mt16tx_Mn_f8 t16tx/DN t16tx/GN VSS VSS nfet L=0.13U W=1U
Mt16tx_Mn_f9 t16tx/DN t16tx/GN VSS VSS nfet L=0.13U W=1U
Mt16tx_Mn_f10 t16tx/DN t16tx/GN VSS VSS nfet L=0.13U W=1U
Mt16tx_Mn_f11 t16tx/DN t16tx/GN VSS VSS nfet L=0.13U W=1U
Mt16tx_Mn_f12 t16tx/DN t16tx/GN VSS VSS nfet L=0.13U W=1U
Mt16tx_Mn_f13 t16tx/DN t16tx/GN VSS VSS nfet L=0.13U W=1U
Mt16tx_Mn_f14 t16tx/DN t16tx/GN VSS VSS nfet L=0.13U W=1U
Mt16tx_Mn_f15 t16tx/DN t16tx/GN VSS VSS nfet L=0.13U W=1U
Mt16tx_Mn_f16 t16tx/DN t16tx/GN VSS VSS nfet L=0.13U W=1U
Mt16tx_Mn_f17 t16tx/DN t16tx/GN VSS VSS nfet L=0.13U W=1U
Mt16tx_Mn_f18 t16tx/DN t16tx/GN VSS VSS nfet L=0.13U W=1U
Mt16tx_Mn_f19 t16tx/DN t16tx/GN VSS VSS nfet L=0.13U W=1U
Mt16tx_Mn_f20 t16tx/DN t16tx/GN VSS VSS nfet L=0.13U W=1U
Mt16tx_Mn_f21 t16tx/DN t16tx/GN VSS VSS nfet L=0.13U W=1U
Mt16tx_Mpu_f0 t16tx/PUX PUN VDDIO VDDIO pfet L=0.13U W=2U
Xt16tx_Rpu t16tx/PUX PAD$8 VSS rppd r=12472.0 L=24U W=0.5U
Mt16tx_Mpd_f0 t16tx/PDX PD VSS VSS nfet L=0.13U W=1U
Xt16tx_Rpd PAD$8 t16tx/PDX VSS rppd r=12472.0 L=24U W=0.5U
Xt16tx_Rsp t16tx/DP PAD$8 VSS rppd r=20.0 L=0.5U W=10U
Xt16tx_Rsn t16tx/DN PAD$8 VSS rppd r=20.0 L=0.5U W=10U
Dt17esd_Dp1 PAD$10 VDDIO diodevdd_mod A=35P P=58.08U
Dt17esd_Dp1_dsub VSS VDDIO dsub_2kv_mod A=224.956P P=81.12U
Mt17esd_Mn1_f0 PAD$10 VSS VSS VSS nfet L=0.13U W=2U
Mt17esd_Mn1_f1 PAD$10 VSS VSS VSS nfet L=0.13U W=2U
Mt17esd_Mn1_f2 PAD$10 VSS VSS VSS nfet L=0.13U W=2U
Mt17esd_Mn1_f3 PAD$10 VSS VSS VSS nfet L=0.13U W=2U
Mt17esd_Mn1_f4 PAD$10 VSS VSS VSS nfet L=0.13U W=2U
Mt17esd_Mn1_f5 PAD$10 VSS VSS VSS nfet L=0.13U W=2U
Mt17esd_Mn1_f6 PAD$10 VSS VSS VSS nfet L=0.13U W=2U
Mt17esd_Mn1_f7 PAD$10 VSS VSS VSS nfet L=0.13U W=2U
Mt17esd_Mn1_f8 PAD$10 VSS VSS VSS nfet L=0.13U W=2U
Mt17esd_Mn1_f9 PAD$10 VSS VSS VSS nfet L=0.13U W=2U
Mt17esd_Mclamp_f0 VDDIO VSS VSS VSS nfet L=0.35U W=2U
Mt17esd_Mclamp_f1 VDDIO VSS VSS VSS nfet L=0.35U W=2U
Mt17esd_Mclamp_f2 VDDIO VSS VSS VSS nfet L=0.35U W=2U
Mt17esd_Mclamp_f3 VDDIO VSS VSS VSS nfet L=0.35U W=2U
Mt17esd_Mclamp_f4 VDDIO VSS VSS VSS nfet L=0.35U W=2U
Mt17esd_Mclamp_f5 VDDIO VSS VSS VSS nfet L=0.35U W=2U
Mt17esd_Mclamp_f6 VDDIO VSS VSS VSS nfet L=0.35U W=2U
Mt17esd_Mclamp_f7 VDDIO VSS VSS VSS nfet L=0.35U W=2U
Mt17esd_Mclamp_f8 VDDIO VSS VSS VSS nfet L=0.35U W=2U
Mt17esd_Mclamp_f9 VDDIO VSS VSS VSS nfet L=0.35U W=2U
Mt17esd_Mclamp_f10 VDDIO VSS VSS VSS nfet L=0.35U W=2U
Mt17esd_Mclamp_f11 VDDIO VSS VSS VSS nfet L=0.35U W=2U
Mt17esd_Mclamp_f12 VDDIO VSS VSS VSS nfet L=0.35U W=2U
Mt17esd_Mclamp_f13 VDDIO VSS VSS VSS nfet L=0.35U W=2U
Mt17esd_Mclamp_f14 VDDIO VSS VSS VSS nfet L=0.35U W=2U
Mt17esd_Mclamp_f15 VDDIO VSS VSS VSS nfet L=0.35U W=2U
Mt17esd_Mclamp_f16 VDDIO VSS VSS VSS nfet L=0.35U W=2U
Mt17esd_Mclamp_f17 VDDIO VSS VSS VSS nfet L=0.35U W=2U
Mt17esd_Mclamp_f18 VDDIO VSS VSS VSS nfet L=0.35U W=2U
Mt17esd_Mclamp_f19 VDDIO VSS VSS VSS nfet L=0.35U W=2U
Xt17esd_Resd PAD$10 PADI_T17 VSS rppd r=164.6 L=1U W=2U
Dt17esd_Dp2 PADI_T17 VDDIO dpantenna A=4P P=8U
Mt17esd_Mn2_f0 PADI_T17 VSS VSS VSS nfet L=0.13U W=1U
Mt17tx_Mi1p_f0 t17tx/OEB OE VDDIO VDDIO pfet L=0.13U W=2U
Mt17tx_Mi1n_f0 t17tx/OEB OE VSS VSS nfet L=0.13U W=1U
Mt17tx_Mnd1p_f0 t17tx/GP DIN$17 VDDIO VDDIO pfet L=0.13U W=2U
Mt17tx_Mnd1p_f1 t17tx/GP DIN$17 VDDIO VDDIO pfet L=0.13U W=2U
Mt17tx_Mnd2p_f0 t17tx/GP OE VDDIO VDDIO pfet L=0.13U W=2U
Mt17tx_Mnd2p_f1 t17tx/GP OE VDDIO VDDIO pfet L=0.13U W=2U
Mt17tx_Mnd1n_f0 t17tx/GP DIN$17 t17tx/NA VSS nfet L=0.13U W=2U
Mt17tx_Mnd1n_f1 t17tx/GP DIN$17 t17tx/NA VSS nfet L=0.13U W=2U
Mt17tx_Mnd2n_f0 t17tx/NA OE VSS VSS nfet L=0.13U W=2U
Mt17tx_Mnd2n_f1 t17tx/NA OE VSS VSS nfet L=0.13U W=2U
Mt17tx_Mnr1p_f0 t17tx/NB DIN$17 VDDIO VDDIO pfet L=0.13U W=2U
Mt17tx_Mnr1p_f1 t17tx/NB DIN$17 VDDIO VDDIO pfet L=0.13U W=2U
Mt17tx_Mnr1p_f2 t17tx/NB DIN$17 VDDIO VDDIO pfet L=0.13U W=2U
Mt17tx_Mnr1p_f3 t17tx/NB DIN$17 VDDIO VDDIO pfet L=0.13U W=2U
Mt17tx_Mnr2p_f0 t17tx/GN t17tx/OEB t17tx/NB VDDIO pfet L=0.13U W=2U
Mt17tx_Mnr2p_f1 t17tx/GN t17tx/OEB t17tx/NB VDDIO pfet L=0.13U W=2U
Mt17tx_Mnr2p_f2 t17tx/GN t17tx/OEB t17tx/NB VDDIO pfet L=0.13U W=2U
Mt17tx_Mnr2p_f3 t17tx/GN t17tx/OEB t17tx/NB VDDIO pfet L=0.13U W=2U
Mt17tx_Mnr1n_f0 t17tx/GN DIN$17 VSS VSS nfet L=0.13U W=1U
Mt17tx_Mnr1n_f1 t17tx/GN DIN$17 VSS VSS nfet L=0.13U W=1U
Mt17tx_Mnr2n_f0 t17tx/GN t17tx/OEB VSS VSS nfet L=0.13U W=1U
Mt17tx_Mnr2n_f1 t17tx/GN t17tx/OEB VSS VSS nfet L=0.13U W=1U
Mt17tx_Mp_f0 t17tx/DP t17tx/GP VDDIO VDDIO pfet L=0.13U W=1U
Mt17tx_Mp_f1 t17tx/DP t17tx/GP VDDIO VDDIO pfet L=0.13U W=1U
Mt17tx_Mp_f2 t17tx/DP t17tx/GP VDDIO VDDIO pfet L=0.13U W=1U
Mt17tx_Mp_f3 t17tx/DP t17tx/GP VDDIO VDDIO pfet L=0.13U W=1U
Mt17tx_Mp_f4 t17tx/DP t17tx/GP VDDIO VDDIO pfet L=0.13U W=1U
Mt17tx_Mp_f5 t17tx/DP t17tx/GP VDDIO VDDIO pfet L=0.13U W=1U
Mt17tx_Mp_f6 t17tx/DP t17tx/GP VDDIO VDDIO pfet L=0.13U W=1U
Mt17tx_Mp_f7 t17tx/DP t17tx/GP VDDIO VDDIO pfet L=0.13U W=1U
Mt17tx_Mp_f8 t17tx/DP t17tx/GP VDDIO VDDIO pfet L=0.13U W=1U
Mt17tx_Mp_f9 t17tx/DP t17tx/GP VDDIO VDDIO pfet L=0.13U W=1U
Mt17tx_Mp_f10 t17tx/DP t17tx/GP VDDIO VDDIO pfet L=0.13U W=1U
Mt17tx_Mp_f11 t17tx/DP t17tx/GP VDDIO VDDIO pfet L=0.13U W=1U
Mt17tx_Mp_f12 t17tx/DP t17tx/GP VDDIO VDDIO pfet L=0.13U W=1U
Mt17tx_Mp_f13 t17tx/DP t17tx/GP VDDIO VDDIO pfet L=0.13U W=1U
Mt17tx_Mp_f14 t17tx/DP t17tx/GP VDDIO VDDIO pfet L=0.13U W=1U
Mt17tx_Mp_f15 t17tx/DP t17tx/GP VDDIO VDDIO pfet L=0.13U W=1U
Mt17tx_Mp_f16 t17tx/DP t17tx/GP VDDIO VDDIO pfet L=0.13U W=1U
Mt17tx_Mp_f17 t17tx/DP t17tx/GP VDDIO VDDIO pfet L=0.13U W=1U
Mt17tx_Mp_f18 t17tx/DP t17tx/GP VDDIO VDDIO pfet L=0.13U W=1U
Mt17tx_Mp_f19 t17tx/DP t17tx/GP VDDIO VDDIO pfet L=0.13U W=1U
Mt17tx_Mp_f20 t17tx/DP t17tx/GP VDDIO VDDIO pfet L=0.13U W=1U
Mt17tx_Mp_f21 t17tx/DP t17tx/GP VDDIO VDDIO pfet L=0.13U W=1U
Mt17tx_Mp_f22 t17tx/DP t17tx/GP VDDIO VDDIO pfet L=0.13U W=1U
Mt17tx_Mp_f23 t17tx/DP t17tx/GP VDDIO VDDIO pfet L=0.13U W=1U
Mt17tx_Mp_f24 t17tx/DP t17tx/GP VDDIO VDDIO pfet L=0.13U W=1U
Mt17tx_Mp_f25 t17tx/DP t17tx/GP VDDIO VDDIO pfet L=0.13U W=1U
Mt17tx_Mp_f26 t17tx/DP t17tx/GP VDDIO VDDIO pfet L=0.13U W=1U
Mt17tx_Mp_f27 t17tx/DP t17tx/GP VDDIO VDDIO pfet L=0.13U W=1U
Mt17tx_Mp_f28 t17tx/DP t17tx/GP VDDIO VDDIO pfet L=0.13U W=1U
Mt17tx_Mp_f29 t17tx/DP t17tx/GP VDDIO VDDIO pfet L=0.13U W=1U
Mt17tx_Mp_f30 t17tx/DP t17tx/GP VDDIO VDDIO pfet L=0.13U W=1U
Mt17tx_Mp_f31 t17tx/DP t17tx/GP VDDIO VDDIO pfet L=0.13U W=1U
Mt17tx_Mp_f32 t17tx/DP t17tx/GP VDDIO VDDIO pfet L=0.13U W=1U
Mt17tx_Mp_f33 t17tx/DP t17tx/GP VDDIO VDDIO pfet L=0.13U W=1U
Mt17tx_Mp_f34 t17tx/DP t17tx/GP VDDIO VDDIO pfet L=0.13U W=1U
Mt17tx_Mp_f35 t17tx/DP t17tx/GP VDDIO VDDIO pfet L=0.13U W=1U
Mt17tx_Mp_f36 t17tx/DP t17tx/GP VDDIO VDDIO pfet L=0.13U W=1U
Mt17tx_Mp_f37 t17tx/DP t17tx/GP VDDIO VDDIO pfet L=0.13U W=1U
Mt17tx_Mp_f38 t17tx/DP t17tx/GP VDDIO VDDIO pfet L=0.13U W=1U
Mt17tx_Mp_f39 t17tx/DP t17tx/GP VDDIO VDDIO pfet L=0.13U W=1U
Mt17tx_Mp_f40 t17tx/DP t17tx/GP VDDIO VDDIO pfet L=0.13U W=1U
Mt17tx_Mp_f41 t17tx/DP t17tx/GP VDDIO VDDIO pfet L=0.13U W=1U
Mt17tx_Mp_f42 t17tx/DP t17tx/GP VDDIO VDDIO pfet L=0.13U W=1U
Mt17tx_Mp_f43 t17tx/DP t17tx/GP VDDIO VDDIO pfet L=0.13U W=1U
Mt17tx_Mp_f44 t17tx/DP t17tx/GP VDDIO VDDIO pfet L=0.13U W=1U
Mt17tx_Mp_f45 t17tx/DP t17tx/GP VDDIO VDDIO pfet L=0.13U W=1U
Mt17tx_Mp_f46 t17tx/DP t17tx/GP VDDIO VDDIO pfet L=0.13U W=1U
Mt17tx_Mp_f47 t17tx/DP t17tx/GP VDDIO VDDIO pfet L=0.13U W=1U
Mt17tx_Mp_f48 t17tx/DP t17tx/GP VDDIO VDDIO pfet L=0.13U W=1U
Mt17tx_Mp_f49 t17tx/DP t17tx/GP VDDIO VDDIO pfet L=0.13U W=1U
Mt17tx_Mp_f50 t17tx/DP t17tx/GP VDDIO VDDIO pfet L=0.13U W=1U
Mt17tx_Mp_f51 t17tx/DP t17tx/GP VDDIO VDDIO pfet L=0.13U W=1U
Mt17tx_Mp_f52 t17tx/DP t17tx/GP VDDIO VDDIO pfet L=0.13U W=1U
Mt17tx_Mp_f53 t17tx/DP t17tx/GP VDDIO VDDIO pfet L=0.13U W=1U
Mt17tx_Mn_f0 t17tx/DN t17tx/GN VSS VSS nfet L=0.13U W=1U
Mt17tx_Mn_f1 t17tx/DN t17tx/GN VSS VSS nfet L=0.13U W=1U
Mt17tx_Mn_f2 t17tx/DN t17tx/GN VSS VSS nfet L=0.13U W=1U
Mt17tx_Mn_f3 t17tx/DN t17tx/GN VSS VSS nfet L=0.13U W=1U
Mt17tx_Mn_f4 t17tx/DN t17tx/GN VSS VSS nfet L=0.13U W=1U
Mt17tx_Mn_f5 t17tx/DN t17tx/GN VSS VSS nfet L=0.13U W=1U
Mt17tx_Mn_f6 t17tx/DN t17tx/GN VSS VSS nfet L=0.13U W=1U
Mt17tx_Mn_f7 t17tx/DN t17tx/GN VSS VSS nfet L=0.13U W=1U
Mt17tx_Mn_f8 t17tx/DN t17tx/GN VSS VSS nfet L=0.13U W=1U
Mt17tx_Mn_f9 t17tx/DN t17tx/GN VSS VSS nfet L=0.13U W=1U
Mt17tx_Mn_f10 t17tx/DN t17tx/GN VSS VSS nfet L=0.13U W=1U
Mt17tx_Mn_f11 t17tx/DN t17tx/GN VSS VSS nfet L=0.13U W=1U
Mt17tx_Mn_f12 t17tx/DN t17tx/GN VSS VSS nfet L=0.13U W=1U
Mt17tx_Mn_f13 t17tx/DN t17tx/GN VSS VSS nfet L=0.13U W=1U
Mt17tx_Mn_f14 t17tx/DN t17tx/GN VSS VSS nfet L=0.13U W=1U
Mt17tx_Mn_f15 t17tx/DN t17tx/GN VSS VSS nfet L=0.13U W=1U
Mt17tx_Mn_f16 t17tx/DN t17tx/GN VSS VSS nfet L=0.13U W=1U
Mt17tx_Mn_f17 t17tx/DN t17tx/GN VSS VSS nfet L=0.13U W=1U
Mt17tx_Mn_f18 t17tx/DN t17tx/GN VSS VSS nfet L=0.13U W=1U
Mt17tx_Mn_f19 t17tx/DN t17tx/GN VSS VSS nfet L=0.13U W=1U
Mt17tx_Mn_f20 t17tx/DN t17tx/GN VSS VSS nfet L=0.13U W=1U
Mt17tx_Mn_f21 t17tx/DN t17tx/GN VSS VSS nfet L=0.13U W=1U
Mt17tx_Mpu_f0 t17tx/PUX PUN VDDIO VDDIO pfet L=0.13U W=2U
Xt17tx_Rpu t17tx/PUX PAD$10 VSS rppd r=12472.0 L=24U W=0.5U
Mt17tx_Mpd_f0 t17tx/PDX PD VSS VSS nfet L=0.13U W=1U
Xt17tx_Rpd PAD$10 t17tx/PDX VSS rppd r=12472.0 L=24U W=0.5U
Xt17tx_Rsp t17tx/DP PAD$10 VSS rppd r=20.0 L=0.5U W=10U
Xt17tx_Rsn t17tx/DN PAD$10 VSS rppd r=20.0 L=0.5U W=10U
Dt18esd_Dp1 PAD$12 VDDIO diodevdd_mod A=35P P=58.08U
Dt18esd_Dp1_dsub VSS VDDIO dsub_2kv_mod A=224.956P P=81.12U
Mt18esd_Mn1_f0 PAD$12 VSS VSS VSS nfet L=0.13U W=2U
Mt18esd_Mn1_f1 PAD$12 VSS VSS VSS nfet L=0.13U W=2U
Mt18esd_Mn1_f2 PAD$12 VSS VSS VSS nfet L=0.13U W=2U
Mt18esd_Mn1_f3 PAD$12 VSS VSS VSS nfet L=0.13U W=2U
Mt18esd_Mn1_f4 PAD$12 VSS VSS VSS nfet L=0.13U W=2U
Mt18esd_Mn1_f5 PAD$12 VSS VSS VSS nfet L=0.13U W=2U
Mt18esd_Mn1_f6 PAD$12 VSS VSS VSS nfet L=0.13U W=2U
Mt18esd_Mn1_f7 PAD$12 VSS VSS VSS nfet L=0.13U W=2U
Mt18esd_Mn1_f8 PAD$12 VSS VSS VSS nfet L=0.13U W=2U
Mt18esd_Mn1_f9 PAD$12 VSS VSS VSS nfet L=0.13U W=2U
Mt18esd_Mclamp_f0 VDDIO VSS VSS VSS nfet L=0.35U W=2U
Mt18esd_Mclamp_f1 VDDIO VSS VSS VSS nfet L=0.35U W=2U
Mt18esd_Mclamp_f2 VDDIO VSS VSS VSS nfet L=0.35U W=2U
Mt18esd_Mclamp_f3 VDDIO VSS VSS VSS nfet L=0.35U W=2U
Mt18esd_Mclamp_f4 VDDIO VSS VSS VSS nfet L=0.35U W=2U
Mt18esd_Mclamp_f5 VDDIO VSS VSS VSS nfet L=0.35U W=2U
Mt18esd_Mclamp_f6 VDDIO VSS VSS VSS nfet L=0.35U W=2U
Mt18esd_Mclamp_f7 VDDIO VSS VSS VSS nfet L=0.35U W=2U
Mt18esd_Mclamp_f8 VDDIO VSS VSS VSS nfet L=0.35U W=2U
Mt18esd_Mclamp_f9 VDDIO VSS VSS VSS nfet L=0.35U W=2U
Mt18esd_Mclamp_f10 VDDIO VSS VSS VSS nfet L=0.35U W=2U
Mt18esd_Mclamp_f11 VDDIO VSS VSS VSS nfet L=0.35U W=2U
Mt18esd_Mclamp_f12 VDDIO VSS VSS VSS nfet L=0.35U W=2U
Mt18esd_Mclamp_f13 VDDIO VSS VSS VSS nfet L=0.35U W=2U
Mt18esd_Mclamp_f14 VDDIO VSS VSS VSS nfet L=0.35U W=2U
Mt18esd_Mclamp_f15 VDDIO VSS VSS VSS nfet L=0.35U W=2U
Mt18esd_Mclamp_f16 VDDIO VSS VSS VSS nfet L=0.35U W=2U
Mt18esd_Mclamp_f17 VDDIO VSS VSS VSS nfet L=0.35U W=2U
Mt18esd_Mclamp_f18 VDDIO VSS VSS VSS nfet L=0.35U W=2U
Mt18esd_Mclamp_f19 VDDIO VSS VSS VSS nfet L=0.35U W=2U
Xt18esd_Resd PAD$12 PADI_T18 VSS rppd r=164.6 L=1U W=2U
Dt18esd_Dp2 PADI_T18 VDDIO dpantenna A=4P P=8U
Mt18esd_Mn2_f0 PADI_T18 VSS VSS VSS nfet L=0.13U W=1U
Mt18tx_Mi1p_f0 t18tx/OEB OE VDDIO VDDIO pfet L=0.13U W=2U
Mt18tx_Mi1n_f0 t18tx/OEB OE VSS VSS nfet L=0.13U W=1U
Mt18tx_Mnd1p_f0 t18tx/GP DIN$18 VDDIO VDDIO pfet L=0.13U W=2U
Mt18tx_Mnd1p_f1 t18tx/GP DIN$18 VDDIO VDDIO pfet L=0.13U W=2U
Mt18tx_Mnd2p_f0 t18tx/GP OE VDDIO VDDIO pfet L=0.13U W=2U
Mt18tx_Mnd2p_f1 t18tx/GP OE VDDIO VDDIO pfet L=0.13U W=2U
Mt18tx_Mnd1n_f0 t18tx/GP DIN$18 t18tx/NA VSS nfet L=0.13U W=2U
Mt18tx_Mnd1n_f1 t18tx/GP DIN$18 t18tx/NA VSS nfet L=0.13U W=2U
Mt18tx_Mnd2n_f0 t18tx/NA OE VSS VSS nfet L=0.13U W=2U
Mt18tx_Mnd2n_f1 t18tx/NA OE VSS VSS nfet L=0.13U W=2U
Mt18tx_Mnr1p_f0 t18tx/NB DIN$18 VDDIO VDDIO pfet L=0.13U W=2U
Mt18tx_Mnr1p_f1 t18tx/NB DIN$18 VDDIO VDDIO pfet L=0.13U W=2U
Mt18tx_Mnr1p_f2 t18tx/NB DIN$18 VDDIO VDDIO pfet L=0.13U W=2U
Mt18tx_Mnr1p_f3 t18tx/NB DIN$18 VDDIO VDDIO pfet L=0.13U W=2U
Mt18tx_Mnr2p_f0 t18tx/GN t18tx/OEB t18tx/NB VDDIO pfet L=0.13U W=2U
Mt18tx_Mnr2p_f1 t18tx/GN t18tx/OEB t18tx/NB VDDIO pfet L=0.13U W=2U
Mt18tx_Mnr2p_f2 t18tx/GN t18tx/OEB t18tx/NB VDDIO pfet L=0.13U W=2U
Mt18tx_Mnr2p_f3 t18tx/GN t18tx/OEB t18tx/NB VDDIO pfet L=0.13U W=2U
Mt18tx_Mnr1n_f0 t18tx/GN DIN$18 VSS VSS nfet L=0.13U W=1U
Mt18tx_Mnr1n_f1 t18tx/GN DIN$18 VSS VSS nfet L=0.13U W=1U
Mt18tx_Mnr2n_f0 t18tx/GN t18tx/OEB VSS VSS nfet L=0.13U W=1U
Mt18tx_Mnr2n_f1 t18tx/GN t18tx/OEB VSS VSS nfet L=0.13U W=1U
Mt18tx_Mp_f0 t18tx/DP t18tx/GP VDDIO VDDIO pfet L=0.13U W=1U
Mt18tx_Mp_f1 t18tx/DP t18tx/GP VDDIO VDDIO pfet L=0.13U W=1U
Mt18tx_Mp_f2 t18tx/DP t18tx/GP VDDIO VDDIO pfet L=0.13U W=1U
Mt18tx_Mp_f3 t18tx/DP t18tx/GP VDDIO VDDIO pfet L=0.13U W=1U
Mt18tx_Mp_f4 t18tx/DP t18tx/GP VDDIO VDDIO pfet L=0.13U W=1U
Mt18tx_Mp_f5 t18tx/DP t18tx/GP VDDIO VDDIO pfet L=0.13U W=1U
Mt18tx_Mp_f6 t18tx/DP t18tx/GP VDDIO VDDIO pfet L=0.13U W=1U
Mt18tx_Mp_f7 t18tx/DP t18tx/GP VDDIO VDDIO pfet L=0.13U W=1U
Mt18tx_Mp_f8 t18tx/DP t18tx/GP VDDIO VDDIO pfet L=0.13U W=1U
Mt18tx_Mp_f9 t18tx/DP t18tx/GP VDDIO VDDIO pfet L=0.13U W=1U
Mt18tx_Mp_f10 t18tx/DP t18tx/GP VDDIO VDDIO pfet L=0.13U W=1U
Mt18tx_Mp_f11 t18tx/DP t18tx/GP VDDIO VDDIO pfet L=0.13U W=1U
Mt18tx_Mp_f12 t18tx/DP t18tx/GP VDDIO VDDIO pfet L=0.13U W=1U
Mt18tx_Mp_f13 t18tx/DP t18tx/GP VDDIO VDDIO pfet L=0.13U W=1U
Mt18tx_Mp_f14 t18tx/DP t18tx/GP VDDIO VDDIO pfet L=0.13U W=1U
Mt18tx_Mp_f15 t18tx/DP t18tx/GP VDDIO VDDIO pfet L=0.13U W=1U
Mt18tx_Mp_f16 t18tx/DP t18tx/GP VDDIO VDDIO pfet L=0.13U W=1U
Mt18tx_Mp_f17 t18tx/DP t18tx/GP VDDIO VDDIO pfet L=0.13U W=1U
Mt18tx_Mp_f18 t18tx/DP t18tx/GP VDDIO VDDIO pfet L=0.13U W=1U
Mt18tx_Mp_f19 t18tx/DP t18tx/GP VDDIO VDDIO pfet L=0.13U W=1U
Mt18tx_Mp_f20 t18tx/DP t18tx/GP VDDIO VDDIO pfet L=0.13U W=1U
Mt18tx_Mp_f21 t18tx/DP t18tx/GP VDDIO VDDIO pfet L=0.13U W=1U
Mt18tx_Mp_f22 t18tx/DP t18tx/GP VDDIO VDDIO pfet L=0.13U W=1U
Mt18tx_Mp_f23 t18tx/DP t18tx/GP VDDIO VDDIO pfet L=0.13U W=1U
Mt18tx_Mp_f24 t18tx/DP t18tx/GP VDDIO VDDIO pfet L=0.13U W=1U
Mt18tx_Mp_f25 t18tx/DP t18tx/GP VDDIO VDDIO pfet L=0.13U W=1U
Mt18tx_Mp_f26 t18tx/DP t18tx/GP VDDIO VDDIO pfet L=0.13U W=1U
Mt18tx_Mp_f27 t18tx/DP t18tx/GP VDDIO VDDIO pfet L=0.13U W=1U
Mt18tx_Mp_f28 t18tx/DP t18tx/GP VDDIO VDDIO pfet L=0.13U W=1U
Mt18tx_Mp_f29 t18tx/DP t18tx/GP VDDIO VDDIO pfet L=0.13U W=1U
Mt18tx_Mp_f30 t18tx/DP t18tx/GP VDDIO VDDIO pfet L=0.13U W=1U
Mt18tx_Mp_f31 t18tx/DP t18tx/GP VDDIO VDDIO pfet L=0.13U W=1U
Mt18tx_Mp_f32 t18tx/DP t18tx/GP VDDIO VDDIO pfet L=0.13U W=1U
Mt18tx_Mp_f33 t18tx/DP t18tx/GP VDDIO VDDIO pfet L=0.13U W=1U
Mt18tx_Mp_f34 t18tx/DP t18tx/GP VDDIO VDDIO pfet L=0.13U W=1U
Mt18tx_Mp_f35 t18tx/DP t18tx/GP VDDIO VDDIO pfet L=0.13U W=1U
Mt18tx_Mp_f36 t18tx/DP t18tx/GP VDDIO VDDIO pfet L=0.13U W=1U
Mt18tx_Mp_f37 t18tx/DP t18tx/GP VDDIO VDDIO pfet L=0.13U W=1U
Mt18tx_Mp_f38 t18tx/DP t18tx/GP VDDIO VDDIO pfet L=0.13U W=1U
Mt18tx_Mp_f39 t18tx/DP t18tx/GP VDDIO VDDIO pfet L=0.13U W=1U
Mt18tx_Mp_f40 t18tx/DP t18tx/GP VDDIO VDDIO pfet L=0.13U W=1U
Mt18tx_Mp_f41 t18tx/DP t18tx/GP VDDIO VDDIO pfet L=0.13U W=1U
Mt18tx_Mp_f42 t18tx/DP t18tx/GP VDDIO VDDIO pfet L=0.13U W=1U
Mt18tx_Mp_f43 t18tx/DP t18tx/GP VDDIO VDDIO pfet L=0.13U W=1U
Mt18tx_Mp_f44 t18tx/DP t18tx/GP VDDIO VDDIO pfet L=0.13U W=1U
Mt18tx_Mp_f45 t18tx/DP t18tx/GP VDDIO VDDIO pfet L=0.13U W=1U
Mt18tx_Mp_f46 t18tx/DP t18tx/GP VDDIO VDDIO pfet L=0.13U W=1U
Mt18tx_Mp_f47 t18tx/DP t18tx/GP VDDIO VDDIO pfet L=0.13U W=1U
Mt18tx_Mp_f48 t18tx/DP t18tx/GP VDDIO VDDIO pfet L=0.13U W=1U
Mt18tx_Mp_f49 t18tx/DP t18tx/GP VDDIO VDDIO pfet L=0.13U W=1U
Mt18tx_Mp_f50 t18tx/DP t18tx/GP VDDIO VDDIO pfet L=0.13U W=1U
Mt18tx_Mp_f51 t18tx/DP t18tx/GP VDDIO VDDIO pfet L=0.13U W=1U
Mt18tx_Mp_f52 t18tx/DP t18tx/GP VDDIO VDDIO pfet L=0.13U W=1U
Mt18tx_Mp_f53 t18tx/DP t18tx/GP VDDIO VDDIO pfet L=0.13U W=1U
Mt18tx_Mn_f0 t18tx/DN t18tx/GN VSS VSS nfet L=0.13U W=1U
Mt18tx_Mn_f1 t18tx/DN t18tx/GN VSS VSS nfet L=0.13U W=1U
Mt18tx_Mn_f2 t18tx/DN t18tx/GN VSS VSS nfet L=0.13U W=1U
Mt18tx_Mn_f3 t18tx/DN t18tx/GN VSS VSS nfet L=0.13U W=1U
Mt18tx_Mn_f4 t18tx/DN t18tx/GN VSS VSS nfet L=0.13U W=1U
Mt18tx_Mn_f5 t18tx/DN t18tx/GN VSS VSS nfet L=0.13U W=1U
Mt18tx_Mn_f6 t18tx/DN t18tx/GN VSS VSS nfet L=0.13U W=1U
Mt18tx_Mn_f7 t18tx/DN t18tx/GN VSS VSS nfet L=0.13U W=1U
Mt18tx_Mn_f8 t18tx/DN t18tx/GN VSS VSS nfet L=0.13U W=1U
Mt18tx_Mn_f9 t18tx/DN t18tx/GN VSS VSS nfet L=0.13U W=1U
Mt18tx_Mn_f10 t18tx/DN t18tx/GN VSS VSS nfet L=0.13U W=1U
Mt18tx_Mn_f11 t18tx/DN t18tx/GN VSS VSS nfet L=0.13U W=1U
Mt18tx_Mn_f12 t18tx/DN t18tx/GN VSS VSS nfet L=0.13U W=1U
Mt18tx_Mn_f13 t18tx/DN t18tx/GN VSS VSS nfet L=0.13U W=1U
Mt18tx_Mn_f14 t18tx/DN t18tx/GN VSS VSS nfet L=0.13U W=1U
Mt18tx_Mn_f15 t18tx/DN t18tx/GN VSS VSS nfet L=0.13U W=1U
Mt18tx_Mn_f16 t18tx/DN t18tx/GN VSS VSS nfet L=0.13U W=1U
Mt18tx_Mn_f17 t18tx/DN t18tx/GN VSS VSS nfet L=0.13U W=1U
Mt18tx_Mn_f18 t18tx/DN t18tx/GN VSS VSS nfet L=0.13U W=1U
Mt18tx_Mn_f19 t18tx/DN t18tx/GN VSS VSS nfet L=0.13U W=1U
Mt18tx_Mn_f20 t18tx/DN t18tx/GN VSS VSS nfet L=0.13U W=1U
Mt18tx_Mn_f21 t18tx/DN t18tx/GN VSS VSS nfet L=0.13U W=1U
Mt18tx_Mpu_f0 t18tx/PUX PUN VDDIO VDDIO pfet L=0.13U W=2U
Xt18tx_Rpu t18tx/PUX PAD$12 VSS rppd r=12472.0 L=24U W=0.5U
Mt18tx_Mpd_f0 t18tx/PDX PD VSS VSS nfet L=0.13U W=1U
Xt18tx_Rpd PAD$12 t18tx/PDX VSS rppd r=12472.0 L=24U W=0.5U
Xt18tx_Rsp t18tx/DP PAD$12 VSS rppd r=20.0 L=0.5U W=10U
Xt18tx_Rsn t18tx/DN PAD$12 VSS rppd r=20.0 L=0.5U W=10U
Dt19esd_Dp1 PAD$14 VDDIO diodevdd_mod A=35P P=58.08U
Dt19esd_Dp1_dsub VSS VDDIO dsub_2kv_mod A=224.956P P=81.12U
Mt19esd_Mn1_f0 PAD$14 VSS VSS VSS nfet L=0.13U W=2U
Mt19esd_Mn1_f1 PAD$14 VSS VSS VSS nfet L=0.13U W=2U
Mt19esd_Mn1_f2 PAD$14 VSS VSS VSS nfet L=0.13U W=2U
Mt19esd_Mn1_f3 PAD$14 VSS VSS VSS nfet L=0.13U W=2U
Mt19esd_Mn1_f4 PAD$14 VSS VSS VSS nfet L=0.13U W=2U
Mt19esd_Mn1_f5 PAD$14 VSS VSS VSS nfet L=0.13U W=2U
Mt19esd_Mn1_f6 PAD$14 VSS VSS VSS nfet L=0.13U W=2U
Mt19esd_Mn1_f7 PAD$14 VSS VSS VSS nfet L=0.13U W=2U
Mt19esd_Mn1_f8 PAD$14 VSS VSS VSS nfet L=0.13U W=2U
Mt19esd_Mn1_f9 PAD$14 VSS VSS VSS nfet L=0.13U W=2U
Mt19esd_Mclamp_f0 VDDIO VSS VSS VSS nfet L=0.35U W=2U
Mt19esd_Mclamp_f1 VDDIO VSS VSS VSS nfet L=0.35U W=2U
Mt19esd_Mclamp_f2 VDDIO VSS VSS VSS nfet L=0.35U W=2U
Mt19esd_Mclamp_f3 VDDIO VSS VSS VSS nfet L=0.35U W=2U
Mt19esd_Mclamp_f4 VDDIO VSS VSS VSS nfet L=0.35U W=2U
Mt19esd_Mclamp_f5 VDDIO VSS VSS VSS nfet L=0.35U W=2U
Mt19esd_Mclamp_f6 VDDIO VSS VSS VSS nfet L=0.35U W=2U
Mt19esd_Mclamp_f7 VDDIO VSS VSS VSS nfet L=0.35U W=2U
Mt19esd_Mclamp_f8 VDDIO VSS VSS VSS nfet L=0.35U W=2U
Mt19esd_Mclamp_f9 VDDIO VSS VSS VSS nfet L=0.35U W=2U
Mt19esd_Mclamp_f10 VDDIO VSS VSS VSS nfet L=0.35U W=2U
Mt19esd_Mclamp_f11 VDDIO VSS VSS VSS nfet L=0.35U W=2U
Mt19esd_Mclamp_f12 VDDIO VSS VSS VSS nfet L=0.35U W=2U
Mt19esd_Mclamp_f13 VDDIO VSS VSS VSS nfet L=0.35U W=2U
Mt19esd_Mclamp_f14 VDDIO VSS VSS VSS nfet L=0.35U W=2U
Mt19esd_Mclamp_f15 VDDIO VSS VSS VSS nfet L=0.35U W=2U
Mt19esd_Mclamp_f16 VDDIO VSS VSS VSS nfet L=0.35U W=2U
Mt19esd_Mclamp_f17 VDDIO VSS VSS VSS nfet L=0.35U W=2U
Mt19esd_Mclamp_f18 VDDIO VSS VSS VSS nfet L=0.35U W=2U
Mt19esd_Mclamp_f19 VDDIO VSS VSS VSS nfet L=0.35U W=2U
Xt19esd_Resd PAD$14 PADI_T19 VSS rppd r=164.6 L=1U W=2U
Dt19esd_Dp2 PADI_T19 VDDIO dpantenna A=4P P=8U
Mt19esd_Mn2_f0 PADI_T19 VSS VSS VSS nfet L=0.13U W=1U
Mt19tx_Mi1p_f0 t19tx/OEB OE VDDIO VDDIO pfet L=0.13U W=2U
Mt19tx_Mi1n_f0 t19tx/OEB OE VSS VSS nfet L=0.13U W=1U
Mt19tx_Mnd1p_f0 t19tx/GP DIN$19 VDDIO VDDIO pfet L=0.13U W=2U
Mt19tx_Mnd1p_f1 t19tx/GP DIN$19 VDDIO VDDIO pfet L=0.13U W=2U
Mt19tx_Mnd2p_f0 t19tx/GP OE VDDIO VDDIO pfet L=0.13U W=2U
Mt19tx_Mnd2p_f1 t19tx/GP OE VDDIO VDDIO pfet L=0.13U W=2U
Mt19tx_Mnd1n_f0 t19tx/GP DIN$19 t19tx/NA VSS nfet L=0.13U W=2U
Mt19tx_Mnd1n_f1 t19tx/GP DIN$19 t19tx/NA VSS nfet L=0.13U W=2U
Mt19tx_Mnd2n_f0 t19tx/NA OE VSS VSS nfet L=0.13U W=2U
Mt19tx_Mnd2n_f1 t19tx/NA OE VSS VSS nfet L=0.13U W=2U
Mt19tx_Mnr1p_f0 t19tx/NB DIN$19 VDDIO VDDIO pfet L=0.13U W=2U
Mt19tx_Mnr1p_f1 t19tx/NB DIN$19 VDDIO VDDIO pfet L=0.13U W=2U
Mt19tx_Mnr1p_f2 t19tx/NB DIN$19 VDDIO VDDIO pfet L=0.13U W=2U
Mt19tx_Mnr1p_f3 t19tx/NB DIN$19 VDDIO VDDIO pfet L=0.13U W=2U
Mt19tx_Mnr2p_f0 t19tx/GN t19tx/OEB t19tx/NB VDDIO pfet L=0.13U W=2U
Mt19tx_Mnr2p_f1 t19tx/GN t19tx/OEB t19tx/NB VDDIO pfet L=0.13U W=2U
Mt19tx_Mnr2p_f2 t19tx/GN t19tx/OEB t19tx/NB VDDIO pfet L=0.13U W=2U
Mt19tx_Mnr2p_f3 t19tx/GN t19tx/OEB t19tx/NB VDDIO pfet L=0.13U W=2U
Mt19tx_Mnr1n_f0 t19tx/GN DIN$19 VSS VSS nfet L=0.13U W=1U
Mt19tx_Mnr1n_f1 t19tx/GN DIN$19 VSS VSS nfet L=0.13U W=1U
Mt19tx_Mnr2n_f0 t19tx/GN t19tx/OEB VSS VSS nfet L=0.13U W=1U
Mt19tx_Mnr2n_f1 t19tx/GN t19tx/OEB VSS VSS nfet L=0.13U W=1U
Mt19tx_Mp_f0 t19tx/DP t19tx/GP VDDIO VDDIO pfet L=0.13U W=1U
Mt19tx_Mp_f1 t19tx/DP t19tx/GP VDDIO VDDIO pfet L=0.13U W=1U
Mt19tx_Mp_f2 t19tx/DP t19tx/GP VDDIO VDDIO pfet L=0.13U W=1U
Mt19tx_Mp_f3 t19tx/DP t19tx/GP VDDIO VDDIO pfet L=0.13U W=1U
Mt19tx_Mp_f4 t19tx/DP t19tx/GP VDDIO VDDIO pfet L=0.13U W=1U
Mt19tx_Mp_f5 t19tx/DP t19tx/GP VDDIO VDDIO pfet L=0.13U W=1U
Mt19tx_Mp_f6 t19tx/DP t19tx/GP VDDIO VDDIO pfet L=0.13U W=1U
Mt19tx_Mp_f7 t19tx/DP t19tx/GP VDDIO VDDIO pfet L=0.13U W=1U
Mt19tx_Mp_f8 t19tx/DP t19tx/GP VDDIO VDDIO pfet L=0.13U W=1U
Mt19tx_Mp_f9 t19tx/DP t19tx/GP VDDIO VDDIO pfet L=0.13U W=1U
Mt19tx_Mp_f10 t19tx/DP t19tx/GP VDDIO VDDIO pfet L=0.13U W=1U
Mt19tx_Mp_f11 t19tx/DP t19tx/GP VDDIO VDDIO pfet L=0.13U W=1U
Mt19tx_Mp_f12 t19tx/DP t19tx/GP VDDIO VDDIO pfet L=0.13U W=1U
Mt19tx_Mp_f13 t19tx/DP t19tx/GP VDDIO VDDIO pfet L=0.13U W=1U
Mt19tx_Mp_f14 t19tx/DP t19tx/GP VDDIO VDDIO pfet L=0.13U W=1U
Mt19tx_Mp_f15 t19tx/DP t19tx/GP VDDIO VDDIO pfet L=0.13U W=1U
Mt19tx_Mp_f16 t19tx/DP t19tx/GP VDDIO VDDIO pfet L=0.13U W=1U
Mt19tx_Mp_f17 t19tx/DP t19tx/GP VDDIO VDDIO pfet L=0.13U W=1U
Mt19tx_Mp_f18 t19tx/DP t19tx/GP VDDIO VDDIO pfet L=0.13U W=1U
Mt19tx_Mp_f19 t19tx/DP t19tx/GP VDDIO VDDIO pfet L=0.13U W=1U
Mt19tx_Mp_f20 t19tx/DP t19tx/GP VDDIO VDDIO pfet L=0.13U W=1U
Mt19tx_Mp_f21 t19tx/DP t19tx/GP VDDIO VDDIO pfet L=0.13U W=1U
Mt19tx_Mp_f22 t19tx/DP t19tx/GP VDDIO VDDIO pfet L=0.13U W=1U
Mt19tx_Mp_f23 t19tx/DP t19tx/GP VDDIO VDDIO pfet L=0.13U W=1U
Mt19tx_Mp_f24 t19tx/DP t19tx/GP VDDIO VDDIO pfet L=0.13U W=1U
Mt19tx_Mp_f25 t19tx/DP t19tx/GP VDDIO VDDIO pfet L=0.13U W=1U
Mt19tx_Mp_f26 t19tx/DP t19tx/GP VDDIO VDDIO pfet L=0.13U W=1U
Mt19tx_Mp_f27 t19tx/DP t19tx/GP VDDIO VDDIO pfet L=0.13U W=1U
Mt19tx_Mp_f28 t19tx/DP t19tx/GP VDDIO VDDIO pfet L=0.13U W=1U
Mt19tx_Mp_f29 t19tx/DP t19tx/GP VDDIO VDDIO pfet L=0.13U W=1U
Mt19tx_Mp_f30 t19tx/DP t19tx/GP VDDIO VDDIO pfet L=0.13U W=1U
Mt19tx_Mp_f31 t19tx/DP t19tx/GP VDDIO VDDIO pfet L=0.13U W=1U
Mt19tx_Mp_f32 t19tx/DP t19tx/GP VDDIO VDDIO pfet L=0.13U W=1U
Mt19tx_Mp_f33 t19tx/DP t19tx/GP VDDIO VDDIO pfet L=0.13U W=1U
Mt19tx_Mp_f34 t19tx/DP t19tx/GP VDDIO VDDIO pfet L=0.13U W=1U
Mt19tx_Mp_f35 t19tx/DP t19tx/GP VDDIO VDDIO pfet L=0.13U W=1U
Mt19tx_Mp_f36 t19tx/DP t19tx/GP VDDIO VDDIO pfet L=0.13U W=1U
Mt19tx_Mp_f37 t19tx/DP t19tx/GP VDDIO VDDIO pfet L=0.13U W=1U
Mt19tx_Mp_f38 t19tx/DP t19tx/GP VDDIO VDDIO pfet L=0.13U W=1U
Mt19tx_Mp_f39 t19tx/DP t19tx/GP VDDIO VDDIO pfet L=0.13U W=1U
Mt19tx_Mp_f40 t19tx/DP t19tx/GP VDDIO VDDIO pfet L=0.13U W=1U
Mt19tx_Mp_f41 t19tx/DP t19tx/GP VDDIO VDDIO pfet L=0.13U W=1U
Mt19tx_Mp_f42 t19tx/DP t19tx/GP VDDIO VDDIO pfet L=0.13U W=1U
Mt19tx_Mp_f43 t19tx/DP t19tx/GP VDDIO VDDIO pfet L=0.13U W=1U
Mt19tx_Mp_f44 t19tx/DP t19tx/GP VDDIO VDDIO pfet L=0.13U W=1U
Mt19tx_Mp_f45 t19tx/DP t19tx/GP VDDIO VDDIO pfet L=0.13U W=1U
Mt19tx_Mp_f46 t19tx/DP t19tx/GP VDDIO VDDIO pfet L=0.13U W=1U
Mt19tx_Mp_f47 t19tx/DP t19tx/GP VDDIO VDDIO pfet L=0.13U W=1U
Mt19tx_Mp_f48 t19tx/DP t19tx/GP VDDIO VDDIO pfet L=0.13U W=1U
Mt19tx_Mp_f49 t19tx/DP t19tx/GP VDDIO VDDIO pfet L=0.13U W=1U
Mt19tx_Mp_f50 t19tx/DP t19tx/GP VDDIO VDDIO pfet L=0.13U W=1U
Mt19tx_Mp_f51 t19tx/DP t19tx/GP VDDIO VDDIO pfet L=0.13U W=1U
Mt19tx_Mp_f52 t19tx/DP t19tx/GP VDDIO VDDIO pfet L=0.13U W=1U
Mt19tx_Mp_f53 t19tx/DP t19tx/GP VDDIO VDDIO pfet L=0.13U W=1U
Mt19tx_Mn_f0 t19tx/DN t19tx/GN VSS VSS nfet L=0.13U W=1U
Mt19tx_Mn_f1 t19tx/DN t19tx/GN VSS VSS nfet L=0.13U W=1U
Mt19tx_Mn_f2 t19tx/DN t19tx/GN VSS VSS nfet L=0.13U W=1U
Mt19tx_Mn_f3 t19tx/DN t19tx/GN VSS VSS nfet L=0.13U W=1U
Mt19tx_Mn_f4 t19tx/DN t19tx/GN VSS VSS nfet L=0.13U W=1U
Mt19tx_Mn_f5 t19tx/DN t19tx/GN VSS VSS nfet L=0.13U W=1U
Mt19tx_Mn_f6 t19tx/DN t19tx/GN VSS VSS nfet L=0.13U W=1U
Mt19tx_Mn_f7 t19tx/DN t19tx/GN VSS VSS nfet L=0.13U W=1U
Mt19tx_Mn_f8 t19tx/DN t19tx/GN VSS VSS nfet L=0.13U W=1U
Mt19tx_Mn_f9 t19tx/DN t19tx/GN VSS VSS nfet L=0.13U W=1U
Mt19tx_Mn_f10 t19tx/DN t19tx/GN VSS VSS nfet L=0.13U W=1U
Mt19tx_Mn_f11 t19tx/DN t19tx/GN VSS VSS nfet L=0.13U W=1U
Mt19tx_Mn_f12 t19tx/DN t19tx/GN VSS VSS nfet L=0.13U W=1U
Mt19tx_Mn_f13 t19tx/DN t19tx/GN VSS VSS nfet L=0.13U W=1U
Mt19tx_Mn_f14 t19tx/DN t19tx/GN VSS VSS nfet L=0.13U W=1U
Mt19tx_Mn_f15 t19tx/DN t19tx/GN VSS VSS nfet L=0.13U W=1U
Mt19tx_Mn_f16 t19tx/DN t19tx/GN VSS VSS nfet L=0.13U W=1U
Mt19tx_Mn_f17 t19tx/DN t19tx/GN VSS VSS nfet L=0.13U W=1U
Mt19tx_Mn_f18 t19tx/DN t19tx/GN VSS VSS nfet L=0.13U W=1U
Mt19tx_Mn_f19 t19tx/DN t19tx/GN VSS VSS nfet L=0.13U W=1U
Mt19tx_Mn_f20 t19tx/DN t19tx/GN VSS VSS nfet L=0.13U W=1U
Mt19tx_Mn_f21 t19tx/DN t19tx/GN VSS VSS nfet L=0.13U W=1U
Mt19tx_Mpu_f0 t19tx/PUX PUN VDDIO VDDIO pfet L=0.13U W=2U
Xt19tx_Rpu t19tx/PUX PAD$14 VSS rppd r=12472.0 L=24U W=0.5U
Mt19tx_Mpd_f0 t19tx/PDX PD VSS VSS nfet L=0.13U W=1U
Xt19tx_Rpd PAD$14 t19tx/PDX VSS rppd r=12472.0 L=24U W=0.5U
Xt19tx_Rsp t19tx/DP PAD$14 VSS rppd r=20.0 L=0.5U W=10U
Xt19tx_Rsn t19tx/DN PAD$14 VSS rppd r=20.0 L=0.5U W=10U
Dt20esd_Dp1 PAD$16 VDDIO diodevdd_mod A=35P P=58.08U
Dt20esd_Dp1_dsub VSS VDDIO dsub_2kv_mod A=224.956P P=81.12U
Mt20esd_Mn1_f0 PAD$16 VSS VSS VSS nfet L=0.13U W=2U
Mt20esd_Mn1_f1 PAD$16 VSS VSS VSS nfet L=0.13U W=2U
Mt20esd_Mn1_f2 PAD$16 VSS VSS VSS nfet L=0.13U W=2U
Mt20esd_Mn1_f3 PAD$16 VSS VSS VSS nfet L=0.13U W=2U
Mt20esd_Mn1_f4 PAD$16 VSS VSS VSS nfet L=0.13U W=2U
Mt20esd_Mn1_f5 PAD$16 VSS VSS VSS nfet L=0.13U W=2U
Mt20esd_Mn1_f6 PAD$16 VSS VSS VSS nfet L=0.13U W=2U
Mt20esd_Mn1_f7 PAD$16 VSS VSS VSS nfet L=0.13U W=2U
Mt20esd_Mn1_f8 PAD$16 VSS VSS VSS nfet L=0.13U W=2U
Mt20esd_Mn1_f9 PAD$16 VSS VSS VSS nfet L=0.13U W=2U
Mt20esd_Mclamp_f0 VDDIO VSS VSS VSS nfet L=0.35U W=2U
Mt20esd_Mclamp_f1 VDDIO VSS VSS VSS nfet L=0.35U W=2U
Mt20esd_Mclamp_f2 VDDIO VSS VSS VSS nfet L=0.35U W=2U
Mt20esd_Mclamp_f3 VDDIO VSS VSS VSS nfet L=0.35U W=2U
Mt20esd_Mclamp_f4 VDDIO VSS VSS VSS nfet L=0.35U W=2U
Mt20esd_Mclamp_f5 VDDIO VSS VSS VSS nfet L=0.35U W=2U
Mt20esd_Mclamp_f6 VDDIO VSS VSS VSS nfet L=0.35U W=2U
Mt20esd_Mclamp_f7 VDDIO VSS VSS VSS nfet L=0.35U W=2U
Mt20esd_Mclamp_f8 VDDIO VSS VSS VSS nfet L=0.35U W=2U
Mt20esd_Mclamp_f9 VDDIO VSS VSS VSS nfet L=0.35U W=2U
Mt20esd_Mclamp_f10 VDDIO VSS VSS VSS nfet L=0.35U W=2U
Mt20esd_Mclamp_f11 VDDIO VSS VSS VSS nfet L=0.35U W=2U
Mt20esd_Mclamp_f12 VDDIO VSS VSS VSS nfet L=0.35U W=2U
Mt20esd_Mclamp_f13 VDDIO VSS VSS VSS nfet L=0.35U W=2U
Mt20esd_Mclamp_f14 VDDIO VSS VSS VSS nfet L=0.35U W=2U
Mt20esd_Mclamp_f15 VDDIO VSS VSS VSS nfet L=0.35U W=2U
Mt20esd_Mclamp_f16 VDDIO VSS VSS VSS nfet L=0.35U W=2U
Mt20esd_Mclamp_f17 VDDIO VSS VSS VSS nfet L=0.35U W=2U
Mt20esd_Mclamp_f18 VDDIO VSS VSS VSS nfet L=0.35U W=2U
Mt20esd_Mclamp_f19 VDDIO VSS VSS VSS nfet L=0.35U W=2U
Xt20esd_Resd PAD$16 PADI_T20 VSS rppd r=164.6 L=1U W=2U
Dt20esd_Dp2 PADI_T20 VDDIO dpantenna A=4P P=8U
Mt20esd_Mn2_f0 PADI_T20 VSS VSS VSS nfet L=0.13U W=1U
Mt20tx_Mi1p_f0 t20tx/OEB OE VDDIO VDDIO pfet L=0.13U W=2U
Mt20tx_Mi1n_f0 t20tx/OEB OE VSS VSS nfet L=0.13U W=1U
Mt20tx_Mnd1p_f0 t20tx/GP DIN$20 VDDIO VDDIO pfet L=0.13U W=2U
Mt20tx_Mnd1p_f1 t20tx/GP DIN$20 VDDIO VDDIO pfet L=0.13U W=2U
Mt20tx_Mnd2p_f0 t20tx/GP OE VDDIO VDDIO pfet L=0.13U W=2U
Mt20tx_Mnd2p_f1 t20tx/GP OE VDDIO VDDIO pfet L=0.13U W=2U
Mt20tx_Mnd1n_f0 t20tx/GP DIN$20 t20tx/NA VSS nfet L=0.13U W=2U
Mt20tx_Mnd1n_f1 t20tx/GP DIN$20 t20tx/NA VSS nfet L=0.13U W=2U
Mt20tx_Mnd2n_f0 t20tx/NA OE VSS VSS nfet L=0.13U W=2U
Mt20tx_Mnd2n_f1 t20tx/NA OE VSS VSS nfet L=0.13U W=2U
Mt20tx_Mnr1p_f0 t20tx/NB DIN$20 VDDIO VDDIO pfet L=0.13U W=2U
Mt20tx_Mnr1p_f1 t20tx/NB DIN$20 VDDIO VDDIO pfet L=0.13U W=2U
Mt20tx_Mnr1p_f2 t20tx/NB DIN$20 VDDIO VDDIO pfet L=0.13U W=2U
Mt20tx_Mnr1p_f3 t20tx/NB DIN$20 VDDIO VDDIO pfet L=0.13U W=2U
Mt20tx_Mnr2p_f0 t20tx/GN t20tx/OEB t20tx/NB VDDIO pfet L=0.13U W=2U
Mt20tx_Mnr2p_f1 t20tx/GN t20tx/OEB t20tx/NB VDDIO pfet L=0.13U W=2U
Mt20tx_Mnr2p_f2 t20tx/GN t20tx/OEB t20tx/NB VDDIO pfet L=0.13U W=2U
Mt20tx_Mnr2p_f3 t20tx/GN t20tx/OEB t20tx/NB VDDIO pfet L=0.13U W=2U
Mt20tx_Mnr1n_f0 t20tx/GN DIN$20 VSS VSS nfet L=0.13U W=1U
Mt20tx_Mnr1n_f1 t20tx/GN DIN$20 VSS VSS nfet L=0.13U W=1U
Mt20tx_Mnr2n_f0 t20tx/GN t20tx/OEB VSS VSS nfet L=0.13U W=1U
Mt20tx_Mnr2n_f1 t20tx/GN t20tx/OEB VSS VSS nfet L=0.13U W=1U
Mt20tx_Mp_f0 t20tx/DP t20tx/GP VDDIO VDDIO pfet L=0.13U W=1U
Mt20tx_Mp_f1 t20tx/DP t20tx/GP VDDIO VDDIO pfet L=0.13U W=1U
Mt20tx_Mp_f2 t20tx/DP t20tx/GP VDDIO VDDIO pfet L=0.13U W=1U
Mt20tx_Mp_f3 t20tx/DP t20tx/GP VDDIO VDDIO pfet L=0.13U W=1U
Mt20tx_Mp_f4 t20tx/DP t20tx/GP VDDIO VDDIO pfet L=0.13U W=1U
Mt20tx_Mp_f5 t20tx/DP t20tx/GP VDDIO VDDIO pfet L=0.13U W=1U
Mt20tx_Mp_f6 t20tx/DP t20tx/GP VDDIO VDDIO pfet L=0.13U W=1U
Mt20tx_Mp_f7 t20tx/DP t20tx/GP VDDIO VDDIO pfet L=0.13U W=1U
Mt20tx_Mp_f8 t20tx/DP t20tx/GP VDDIO VDDIO pfet L=0.13U W=1U
Mt20tx_Mp_f9 t20tx/DP t20tx/GP VDDIO VDDIO pfet L=0.13U W=1U
Mt20tx_Mp_f10 t20tx/DP t20tx/GP VDDIO VDDIO pfet L=0.13U W=1U
Mt20tx_Mp_f11 t20tx/DP t20tx/GP VDDIO VDDIO pfet L=0.13U W=1U
Mt20tx_Mp_f12 t20tx/DP t20tx/GP VDDIO VDDIO pfet L=0.13U W=1U
Mt20tx_Mp_f13 t20tx/DP t20tx/GP VDDIO VDDIO pfet L=0.13U W=1U
Mt20tx_Mp_f14 t20tx/DP t20tx/GP VDDIO VDDIO pfet L=0.13U W=1U
Mt20tx_Mp_f15 t20tx/DP t20tx/GP VDDIO VDDIO pfet L=0.13U W=1U
Mt20tx_Mp_f16 t20tx/DP t20tx/GP VDDIO VDDIO pfet L=0.13U W=1U
Mt20tx_Mp_f17 t20tx/DP t20tx/GP VDDIO VDDIO pfet L=0.13U W=1U
Mt20tx_Mp_f18 t20tx/DP t20tx/GP VDDIO VDDIO pfet L=0.13U W=1U
Mt20tx_Mp_f19 t20tx/DP t20tx/GP VDDIO VDDIO pfet L=0.13U W=1U
Mt20tx_Mp_f20 t20tx/DP t20tx/GP VDDIO VDDIO pfet L=0.13U W=1U
Mt20tx_Mp_f21 t20tx/DP t20tx/GP VDDIO VDDIO pfet L=0.13U W=1U
Mt20tx_Mp_f22 t20tx/DP t20tx/GP VDDIO VDDIO pfet L=0.13U W=1U
Mt20tx_Mp_f23 t20tx/DP t20tx/GP VDDIO VDDIO pfet L=0.13U W=1U
Mt20tx_Mp_f24 t20tx/DP t20tx/GP VDDIO VDDIO pfet L=0.13U W=1U
Mt20tx_Mp_f25 t20tx/DP t20tx/GP VDDIO VDDIO pfet L=0.13U W=1U
Mt20tx_Mp_f26 t20tx/DP t20tx/GP VDDIO VDDIO pfet L=0.13U W=1U
Mt20tx_Mp_f27 t20tx/DP t20tx/GP VDDIO VDDIO pfet L=0.13U W=1U
Mt20tx_Mp_f28 t20tx/DP t20tx/GP VDDIO VDDIO pfet L=0.13U W=1U
Mt20tx_Mp_f29 t20tx/DP t20tx/GP VDDIO VDDIO pfet L=0.13U W=1U
Mt20tx_Mp_f30 t20tx/DP t20tx/GP VDDIO VDDIO pfet L=0.13U W=1U
Mt20tx_Mp_f31 t20tx/DP t20tx/GP VDDIO VDDIO pfet L=0.13U W=1U
Mt20tx_Mp_f32 t20tx/DP t20tx/GP VDDIO VDDIO pfet L=0.13U W=1U
Mt20tx_Mp_f33 t20tx/DP t20tx/GP VDDIO VDDIO pfet L=0.13U W=1U
Mt20tx_Mp_f34 t20tx/DP t20tx/GP VDDIO VDDIO pfet L=0.13U W=1U
Mt20tx_Mp_f35 t20tx/DP t20tx/GP VDDIO VDDIO pfet L=0.13U W=1U
Mt20tx_Mp_f36 t20tx/DP t20tx/GP VDDIO VDDIO pfet L=0.13U W=1U
Mt20tx_Mp_f37 t20tx/DP t20tx/GP VDDIO VDDIO pfet L=0.13U W=1U
Mt20tx_Mp_f38 t20tx/DP t20tx/GP VDDIO VDDIO pfet L=0.13U W=1U
Mt20tx_Mp_f39 t20tx/DP t20tx/GP VDDIO VDDIO pfet L=0.13U W=1U
Mt20tx_Mp_f40 t20tx/DP t20tx/GP VDDIO VDDIO pfet L=0.13U W=1U
Mt20tx_Mp_f41 t20tx/DP t20tx/GP VDDIO VDDIO pfet L=0.13U W=1U
Mt20tx_Mp_f42 t20tx/DP t20tx/GP VDDIO VDDIO pfet L=0.13U W=1U
Mt20tx_Mp_f43 t20tx/DP t20tx/GP VDDIO VDDIO pfet L=0.13U W=1U
Mt20tx_Mp_f44 t20tx/DP t20tx/GP VDDIO VDDIO pfet L=0.13U W=1U
Mt20tx_Mp_f45 t20tx/DP t20tx/GP VDDIO VDDIO pfet L=0.13U W=1U
Mt20tx_Mp_f46 t20tx/DP t20tx/GP VDDIO VDDIO pfet L=0.13U W=1U
Mt20tx_Mp_f47 t20tx/DP t20tx/GP VDDIO VDDIO pfet L=0.13U W=1U
Mt20tx_Mp_f48 t20tx/DP t20tx/GP VDDIO VDDIO pfet L=0.13U W=1U
Mt20tx_Mp_f49 t20tx/DP t20tx/GP VDDIO VDDIO pfet L=0.13U W=1U
Mt20tx_Mp_f50 t20tx/DP t20tx/GP VDDIO VDDIO pfet L=0.13U W=1U
Mt20tx_Mp_f51 t20tx/DP t20tx/GP VDDIO VDDIO pfet L=0.13U W=1U
Mt20tx_Mp_f52 t20tx/DP t20tx/GP VDDIO VDDIO pfet L=0.13U W=1U
Mt20tx_Mp_f53 t20tx/DP t20tx/GP VDDIO VDDIO pfet L=0.13U W=1U
Mt20tx_Mn_f0 t20tx/DN t20tx/GN VSS VSS nfet L=0.13U W=1U
Mt20tx_Mn_f1 t20tx/DN t20tx/GN VSS VSS nfet L=0.13U W=1U
Mt20tx_Mn_f2 t20tx/DN t20tx/GN VSS VSS nfet L=0.13U W=1U
Mt20tx_Mn_f3 t20tx/DN t20tx/GN VSS VSS nfet L=0.13U W=1U
Mt20tx_Mn_f4 t20tx/DN t20tx/GN VSS VSS nfet L=0.13U W=1U
Mt20tx_Mn_f5 t20tx/DN t20tx/GN VSS VSS nfet L=0.13U W=1U
Mt20tx_Mn_f6 t20tx/DN t20tx/GN VSS VSS nfet L=0.13U W=1U
Mt20tx_Mn_f7 t20tx/DN t20tx/GN VSS VSS nfet L=0.13U W=1U
Mt20tx_Mn_f8 t20tx/DN t20tx/GN VSS VSS nfet L=0.13U W=1U
Mt20tx_Mn_f9 t20tx/DN t20tx/GN VSS VSS nfet L=0.13U W=1U
Mt20tx_Mn_f10 t20tx/DN t20tx/GN VSS VSS nfet L=0.13U W=1U
Mt20tx_Mn_f11 t20tx/DN t20tx/GN VSS VSS nfet L=0.13U W=1U
Mt20tx_Mn_f12 t20tx/DN t20tx/GN VSS VSS nfet L=0.13U W=1U
Mt20tx_Mn_f13 t20tx/DN t20tx/GN VSS VSS nfet L=0.13U W=1U
Mt20tx_Mn_f14 t20tx/DN t20tx/GN VSS VSS nfet L=0.13U W=1U
Mt20tx_Mn_f15 t20tx/DN t20tx/GN VSS VSS nfet L=0.13U W=1U
Mt20tx_Mn_f16 t20tx/DN t20tx/GN VSS VSS nfet L=0.13U W=1U
Mt20tx_Mn_f17 t20tx/DN t20tx/GN VSS VSS nfet L=0.13U W=1U
Mt20tx_Mn_f18 t20tx/DN t20tx/GN VSS VSS nfet L=0.13U W=1U
Mt20tx_Mn_f19 t20tx/DN t20tx/GN VSS VSS nfet L=0.13U W=1U
Mt20tx_Mn_f20 t20tx/DN t20tx/GN VSS VSS nfet L=0.13U W=1U
Mt20tx_Mn_f21 t20tx/DN t20tx/GN VSS VSS nfet L=0.13U W=1U
Mt20tx_Mpu_f0 t20tx/PUX PUN VDDIO VDDIO pfet L=0.13U W=2U
Xt20tx_Rpu t20tx/PUX PAD$16 VSS rppd r=12472.0 L=24U W=0.5U
Mt20tx_Mpd_f0 t20tx/PDX PD VSS VSS nfet L=0.13U W=1U
Xt20tx_Rpd PAD$16 t20tx/PDX VSS rppd r=12472.0 L=24U W=0.5U
Xt20tx_Rsp t20tx/DP PAD$16 VSS rppd r=20.0 L=0.5U W=10U
Xt20tx_Rsn t20tx/DN PAD$16 VSS rppd r=20.0 L=0.5U W=10U
Dt21esd_Dp1 PAD$18 VDDIO diodevdd_mod A=35P P=58.08U
Dt21esd_Dp1_dsub VSS VDDIO dsub_2kv_mod A=224.956P P=81.12U
Mt21esd_Mn1_f0 PAD$18 VSS VSS VSS nfet L=0.13U W=2U
Mt21esd_Mn1_f1 PAD$18 VSS VSS VSS nfet L=0.13U W=2U
Mt21esd_Mn1_f2 PAD$18 VSS VSS VSS nfet L=0.13U W=2U
Mt21esd_Mn1_f3 PAD$18 VSS VSS VSS nfet L=0.13U W=2U
Mt21esd_Mn1_f4 PAD$18 VSS VSS VSS nfet L=0.13U W=2U
Mt21esd_Mn1_f5 PAD$18 VSS VSS VSS nfet L=0.13U W=2U
Mt21esd_Mn1_f6 PAD$18 VSS VSS VSS nfet L=0.13U W=2U
Mt21esd_Mn1_f7 PAD$18 VSS VSS VSS nfet L=0.13U W=2U
Mt21esd_Mn1_f8 PAD$18 VSS VSS VSS nfet L=0.13U W=2U
Mt21esd_Mn1_f9 PAD$18 VSS VSS VSS nfet L=0.13U W=2U
Mt21esd_Mclamp_f0 VDDIO VSS VSS VSS nfet L=0.35U W=2U
Mt21esd_Mclamp_f1 VDDIO VSS VSS VSS nfet L=0.35U W=2U
Mt21esd_Mclamp_f2 VDDIO VSS VSS VSS nfet L=0.35U W=2U
Mt21esd_Mclamp_f3 VDDIO VSS VSS VSS nfet L=0.35U W=2U
Mt21esd_Mclamp_f4 VDDIO VSS VSS VSS nfet L=0.35U W=2U
Mt21esd_Mclamp_f5 VDDIO VSS VSS VSS nfet L=0.35U W=2U
Mt21esd_Mclamp_f6 VDDIO VSS VSS VSS nfet L=0.35U W=2U
Mt21esd_Mclamp_f7 VDDIO VSS VSS VSS nfet L=0.35U W=2U
Mt21esd_Mclamp_f8 VDDIO VSS VSS VSS nfet L=0.35U W=2U
Mt21esd_Mclamp_f9 VDDIO VSS VSS VSS nfet L=0.35U W=2U
Mt21esd_Mclamp_f10 VDDIO VSS VSS VSS nfet L=0.35U W=2U
Mt21esd_Mclamp_f11 VDDIO VSS VSS VSS nfet L=0.35U W=2U
Mt21esd_Mclamp_f12 VDDIO VSS VSS VSS nfet L=0.35U W=2U
Mt21esd_Mclamp_f13 VDDIO VSS VSS VSS nfet L=0.35U W=2U
Mt21esd_Mclamp_f14 VDDIO VSS VSS VSS nfet L=0.35U W=2U
Mt21esd_Mclamp_f15 VDDIO VSS VSS VSS nfet L=0.35U W=2U
Mt21esd_Mclamp_f16 VDDIO VSS VSS VSS nfet L=0.35U W=2U
Mt21esd_Mclamp_f17 VDDIO VSS VSS VSS nfet L=0.35U W=2U
Mt21esd_Mclamp_f18 VDDIO VSS VSS VSS nfet L=0.35U W=2U
Mt21esd_Mclamp_f19 VDDIO VSS VSS VSS nfet L=0.35U W=2U
Xt21esd_Resd PAD$18 PADI_T21 VSS rppd r=164.6 L=1U W=2U
Dt21esd_Dp2 PADI_T21 VDDIO dpantenna A=4P P=8U
Mt21esd_Mn2_f0 PADI_T21 VSS VSS VSS nfet L=0.13U W=1U
Mt21tx_Mi1p_f0 t21tx/OEB OE VDDIO VDDIO pfet L=0.13U W=2U
Mt21tx_Mi1n_f0 t21tx/OEB OE VSS VSS nfet L=0.13U W=1U
Mt21tx_Mnd1p_f0 t21tx/GP DIN$21 VDDIO VDDIO pfet L=0.13U W=2U
Mt21tx_Mnd1p_f1 t21tx/GP DIN$21 VDDIO VDDIO pfet L=0.13U W=2U
Mt21tx_Mnd2p_f0 t21tx/GP OE VDDIO VDDIO pfet L=0.13U W=2U
Mt21tx_Mnd2p_f1 t21tx/GP OE VDDIO VDDIO pfet L=0.13U W=2U
Mt21tx_Mnd1n_f0 t21tx/GP DIN$21 t21tx/NA VSS nfet L=0.13U W=2U
Mt21tx_Mnd1n_f1 t21tx/GP DIN$21 t21tx/NA VSS nfet L=0.13U W=2U
Mt21tx_Mnd2n_f0 t21tx/NA OE VSS VSS nfet L=0.13U W=2U
Mt21tx_Mnd2n_f1 t21tx/NA OE VSS VSS nfet L=0.13U W=2U
Mt21tx_Mnr1p_f0 t21tx/NB DIN$21 VDDIO VDDIO pfet L=0.13U W=2U
Mt21tx_Mnr1p_f1 t21tx/NB DIN$21 VDDIO VDDIO pfet L=0.13U W=2U
Mt21tx_Mnr1p_f2 t21tx/NB DIN$21 VDDIO VDDIO pfet L=0.13U W=2U
Mt21tx_Mnr1p_f3 t21tx/NB DIN$21 VDDIO VDDIO pfet L=0.13U W=2U
Mt21tx_Mnr2p_f0 t21tx/GN t21tx/OEB t21tx/NB VDDIO pfet L=0.13U W=2U
Mt21tx_Mnr2p_f1 t21tx/GN t21tx/OEB t21tx/NB VDDIO pfet L=0.13U W=2U
Mt21tx_Mnr2p_f2 t21tx/GN t21tx/OEB t21tx/NB VDDIO pfet L=0.13U W=2U
Mt21tx_Mnr2p_f3 t21tx/GN t21tx/OEB t21tx/NB VDDIO pfet L=0.13U W=2U
Mt21tx_Mnr1n_f0 t21tx/GN DIN$21 VSS VSS nfet L=0.13U W=1U
Mt21tx_Mnr1n_f1 t21tx/GN DIN$21 VSS VSS nfet L=0.13U W=1U
Mt21tx_Mnr2n_f0 t21tx/GN t21tx/OEB VSS VSS nfet L=0.13U W=1U
Mt21tx_Mnr2n_f1 t21tx/GN t21tx/OEB VSS VSS nfet L=0.13U W=1U
Mt21tx_Mp_f0 t21tx/DP t21tx/GP VDDIO VDDIO pfet L=0.13U W=1U
Mt21tx_Mp_f1 t21tx/DP t21tx/GP VDDIO VDDIO pfet L=0.13U W=1U
Mt21tx_Mp_f2 t21tx/DP t21tx/GP VDDIO VDDIO pfet L=0.13U W=1U
Mt21tx_Mp_f3 t21tx/DP t21tx/GP VDDIO VDDIO pfet L=0.13U W=1U
Mt21tx_Mp_f4 t21tx/DP t21tx/GP VDDIO VDDIO pfet L=0.13U W=1U
Mt21tx_Mp_f5 t21tx/DP t21tx/GP VDDIO VDDIO pfet L=0.13U W=1U
Mt21tx_Mp_f6 t21tx/DP t21tx/GP VDDIO VDDIO pfet L=0.13U W=1U
Mt21tx_Mp_f7 t21tx/DP t21tx/GP VDDIO VDDIO pfet L=0.13U W=1U
Mt21tx_Mp_f8 t21tx/DP t21tx/GP VDDIO VDDIO pfet L=0.13U W=1U
Mt21tx_Mp_f9 t21tx/DP t21tx/GP VDDIO VDDIO pfet L=0.13U W=1U
Mt21tx_Mp_f10 t21tx/DP t21tx/GP VDDIO VDDIO pfet L=0.13U W=1U
Mt21tx_Mp_f11 t21tx/DP t21tx/GP VDDIO VDDIO pfet L=0.13U W=1U
Mt21tx_Mp_f12 t21tx/DP t21tx/GP VDDIO VDDIO pfet L=0.13U W=1U
Mt21tx_Mp_f13 t21tx/DP t21tx/GP VDDIO VDDIO pfet L=0.13U W=1U
Mt21tx_Mp_f14 t21tx/DP t21tx/GP VDDIO VDDIO pfet L=0.13U W=1U
Mt21tx_Mp_f15 t21tx/DP t21tx/GP VDDIO VDDIO pfet L=0.13U W=1U
Mt21tx_Mp_f16 t21tx/DP t21tx/GP VDDIO VDDIO pfet L=0.13U W=1U
Mt21tx_Mp_f17 t21tx/DP t21tx/GP VDDIO VDDIO pfet L=0.13U W=1U
Mt21tx_Mp_f18 t21tx/DP t21tx/GP VDDIO VDDIO pfet L=0.13U W=1U
Mt21tx_Mp_f19 t21tx/DP t21tx/GP VDDIO VDDIO pfet L=0.13U W=1U
Mt21tx_Mp_f20 t21tx/DP t21tx/GP VDDIO VDDIO pfet L=0.13U W=1U
Mt21tx_Mp_f21 t21tx/DP t21tx/GP VDDIO VDDIO pfet L=0.13U W=1U
Mt21tx_Mp_f22 t21tx/DP t21tx/GP VDDIO VDDIO pfet L=0.13U W=1U
Mt21tx_Mp_f23 t21tx/DP t21tx/GP VDDIO VDDIO pfet L=0.13U W=1U
Mt21tx_Mp_f24 t21tx/DP t21tx/GP VDDIO VDDIO pfet L=0.13U W=1U
Mt21tx_Mp_f25 t21tx/DP t21tx/GP VDDIO VDDIO pfet L=0.13U W=1U
Mt21tx_Mp_f26 t21tx/DP t21tx/GP VDDIO VDDIO pfet L=0.13U W=1U
Mt21tx_Mp_f27 t21tx/DP t21tx/GP VDDIO VDDIO pfet L=0.13U W=1U
Mt21tx_Mp_f28 t21tx/DP t21tx/GP VDDIO VDDIO pfet L=0.13U W=1U
Mt21tx_Mp_f29 t21tx/DP t21tx/GP VDDIO VDDIO pfet L=0.13U W=1U
Mt21tx_Mp_f30 t21tx/DP t21tx/GP VDDIO VDDIO pfet L=0.13U W=1U
Mt21tx_Mp_f31 t21tx/DP t21tx/GP VDDIO VDDIO pfet L=0.13U W=1U
Mt21tx_Mp_f32 t21tx/DP t21tx/GP VDDIO VDDIO pfet L=0.13U W=1U
Mt21tx_Mp_f33 t21tx/DP t21tx/GP VDDIO VDDIO pfet L=0.13U W=1U
Mt21tx_Mp_f34 t21tx/DP t21tx/GP VDDIO VDDIO pfet L=0.13U W=1U
Mt21tx_Mp_f35 t21tx/DP t21tx/GP VDDIO VDDIO pfet L=0.13U W=1U
Mt21tx_Mp_f36 t21tx/DP t21tx/GP VDDIO VDDIO pfet L=0.13U W=1U
Mt21tx_Mp_f37 t21tx/DP t21tx/GP VDDIO VDDIO pfet L=0.13U W=1U
Mt21tx_Mp_f38 t21tx/DP t21tx/GP VDDIO VDDIO pfet L=0.13U W=1U
Mt21tx_Mp_f39 t21tx/DP t21tx/GP VDDIO VDDIO pfet L=0.13U W=1U
Mt21tx_Mp_f40 t21tx/DP t21tx/GP VDDIO VDDIO pfet L=0.13U W=1U
Mt21tx_Mp_f41 t21tx/DP t21tx/GP VDDIO VDDIO pfet L=0.13U W=1U
Mt21tx_Mp_f42 t21tx/DP t21tx/GP VDDIO VDDIO pfet L=0.13U W=1U
Mt21tx_Mp_f43 t21tx/DP t21tx/GP VDDIO VDDIO pfet L=0.13U W=1U
Mt21tx_Mp_f44 t21tx/DP t21tx/GP VDDIO VDDIO pfet L=0.13U W=1U
Mt21tx_Mp_f45 t21tx/DP t21tx/GP VDDIO VDDIO pfet L=0.13U W=1U
Mt21tx_Mp_f46 t21tx/DP t21tx/GP VDDIO VDDIO pfet L=0.13U W=1U
Mt21tx_Mp_f47 t21tx/DP t21tx/GP VDDIO VDDIO pfet L=0.13U W=1U
Mt21tx_Mp_f48 t21tx/DP t21tx/GP VDDIO VDDIO pfet L=0.13U W=1U
Mt21tx_Mp_f49 t21tx/DP t21tx/GP VDDIO VDDIO pfet L=0.13U W=1U
Mt21tx_Mp_f50 t21tx/DP t21tx/GP VDDIO VDDIO pfet L=0.13U W=1U
Mt21tx_Mp_f51 t21tx/DP t21tx/GP VDDIO VDDIO pfet L=0.13U W=1U
Mt21tx_Mp_f52 t21tx/DP t21tx/GP VDDIO VDDIO pfet L=0.13U W=1U
Mt21tx_Mp_f53 t21tx/DP t21tx/GP VDDIO VDDIO pfet L=0.13U W=1U
Mt21tx_Mn_f0 t21tx/DN t21tx/GN VSS VSS nfet L=0.13U W=1U
Mt21tx_Mn_f1 t21tx/DN t21tx/GN VSS VSS nfet L=0.13U W=1U
Mt21tx_Mn_f2 t21tx/DN t21tx/GN VSS VSS nfet L=0.13U W=1U
Mt21tx_Mn_f3 t21tx/DN t21tx/GN VSS VSS nfet L=0.13U W=1U
Mt21tx_Mn_f4 t21tx/DN t21tx/GN VSS VSS nfet L=0.13U W=1U
Mt21tx_Mn_f5 t21tx/DN t21tx/GN VSS VSS nfet L=0.13U W=1U
Mt21tx_Mn_f6 t21tx/DN t21tx/GN VSS VSS nfet L=0.13U W=1U
Mt21tx_Mn_f7 t21tx/DN t21tx/GN VSS VSS nfet L=0.13U W=1U
Mt21tx_Mn_f8 t21tx/DN t21tx/GN VSS VSS nfet L=0.13U W=1U
Mt21tx_Mn_f9 t21tx/DN t21tx/GN VSS VSS nfet L=0.13U W=1U
Mt21tx_Mn_f10 t21tx/DN t21tx/GN VSS VSS nfet L=0.13U W=1U
Mt21tx_Mn_f11 t21tx/DN t21tx/GN VSS VSS nfet L=0.13U W=1U
Mt21tx_Mn_f12 t21tx/DN t21tx/GN VSS VSS nfet L=0.13U W=1U
Mt21tx_Mn_f13 t21tx/DN t21tx/GN VSS VSS nfet L=0.13U W=1U
Mt21tx_Mn_f14 t21tx/DN t21tx/GN VSS VSS nfet L=0.13U W=1U
Mt21tx_Mn_f15 t21tx/DN t21tx/GN VSS VSS nfet L=0.13U W=1U
Mt21tx_Mn_f16 t21tx/DN t21tx/GN VSS VSS nfet L=0.13U W=1U
Mt21tx_Mn_f17 t21tx/DN t21tx/GN VSS VSS nfet L=0.13U W=1U
Mt21tx_Mn_f18 t21tx/DN t21tx/GN VSS VSS nfet L=0.13U W=1U
Mt21tx_Mn_f19 t21tx/DN t21tx/GN VSS VSS nfet L=0.13U W=1U
Mt21tx_Mn_f20 t21tx/DN t21tx/GN VSS VSS nfet L=0.13U W=1U
Mt21tx_Mn_f21 t21tx/DN t21tx/GN VSS VSS nfet L=0.13U W=1U
Mt21tx_Mpu_f0 t21tx/PUX PUN VDDIO VDDIO pfet L=0.13U W=2U
Xt21tx_Rpu t21tx/PUX PAD$18 VSS rppd r=12472.0 L=24U W=0.5U
Mt21tx_Mpd_f0 t21tx/PDX PD VSS VSS nfet L=0.13U W=1U
Xt21tx_Rpd PAD$18 t21tx/PDX VSS rppd r=12472.0 L=24U W=0.5U
Xt21tx_Rsp t21tx/DP PAD$18 VSS rppd r=20.0 L=0.5U W=10U
Xt21tx_Rsn t21tx/DN PAD$18 VSS rppd r=20.0 L=0.5U W=10U
Dt22esd_Dp1 PAD$20 VDDIO diodevdd_mod A=35P P=58.08U
Dt22esd_Dp1_dsub VSS VDDIO dsub_2kv_mod A=224.956P P=81.12U
Mt22esd_Mn1_f0 PAD$20 VSS VSS VSS nfet L=0.13U W=2U
Mt22esd_Mn1_f1 PAD$20 VSS VSS VSS nfet L=0.13U W=2U
Mt22esd_Mn1_f2 PAD$20 VSS VSS VSS nfet L=0.13U W=2U
Mt22esd_Mn1_f3 PAD$20 VSS VSS VSS nfet L=0.13U W=2U
Mt22esd_Mn1_f4 PAD$20 VSS VSS VSS nfet L=0.13U W=2U
Mt22esd_Mn1_f5 PAD$20 VSS VSS VSS nfet L=0.13U W=2U
Mt22esd_Mn1_f6 PAD$20 VSS VSS VSS nfet L=0.13U W=2U
Mt22esd_Mn1_f7 PAD$20 VSS VSS VSS nfet L=0.13U W=2U
Mt22esd_Mn1_f8 PAD$20 VSS VSS VSS nfet L=0.13U W=2U
Mt22esd_Mn1_f9 PAD$20 VSS VSS VSS nfet L=0.13U W=2U
Mt22esd_Mclamp_f0 VDDIO VSS VSS VSS nfet L=0.35U W=2U
Mt22esd_Mclamp_f1 VDDIO VSS VSS VSS nfet L=0.35U W=2U
Mt22esd_Mclamp_f2 VDDIO VSS VSS VSS nfet L=0.35U W=2U
Mt22esd_Mclamp_f3 VDDIO VSS VSS VSS nfet L=0.35U W=2U
Mt22esd_Mclamp_f4 VDDIO VSS VSS VSS nfet L=0.35U W=2U
Mt22esd_Mclamp_f5 VDDIO VSS VSS VSS nfet L=0.35U W=2U
Mt22esd_Mclamp_f6 VDDIO VSS VSS VSS nfet L=0.35U W=2U
Mt22esd_Mclamp_f7 VDDIO VSS VSS VSS nfet L=0.35U W=2U
Mt22esd_Mclamp_f8 VDDIO VSS VSS VSS nfet L=0.35U W=2U
Mt22esd_Mclamp_f9 VDDIO VSS VSS VSS nfet L=0.35U W=2U
Mt22esd_Mclamp_f10 VDDIO VSS VSS VSS nfet L=0.35U W=2U
Mt22esd_Mclamp_f11 VDDIO VSS VSS VSS nfet L=0.35U W=2U
Mt22esd_Mclamp_f12 VDDIO VSS VSS VSS nfet L=0.35U W=2U
Mt22esd_Mclamp_f13 VDDIO VSS VSS VSS nfet L=0.35U W=2U
Mt22esd_Mclamp_f14 VDDIO VSS VSS VSS nfet L=0.35U W=2U
Mt22esd_Mclamp_f15 VDDIO VSS VSS VSS nfet L=0.35U W=2U
Mt22esd_Mclamp_f16 VDDIO VSS VSS VSS nfet L=0.35U W=2U
Mt22esd_Mclamp_f17 VDDIO VSS VSS VSS nfet L=0.35U W=2U
Mt22esd_Mclamp_f18 VDDIO VSS VSS VSS nfet L=0.35U W=2U
Mt22esd_Mclamp_f19 VDDIO VSS VSS VSS nfet L=0.35U W=2U
Xt22esd_Resd PAD$20 PADI_T22 VSS rppd r=164.6 L=1U W=2U
Dt22esd_Dp2 PADI_T22 VDDIO dpantenna A=4P P=8U
Mt22esd_Mn2_f0 PADI_T22 VSS VSS VSS nfet L=0.13U W=1U
Mt22tx_Mi1p_f0 t22tx/OEB OE VDDIO VDDIO pfet L=0.13U W=2U
Mt22tx_Mi1n_f0 t22tx/OEB OE VSS VSS nfet L=0.13U W=1U
Mt22tx_Mnd1p_f0 t22tx/GP DIN$22 VDDIO VDDIO pfet L=0.13U W=2U
Mt22tx_Mnd1p_f1 t22tx/GP DIN$22 VDDIO VDDIO pfet L=0.13U W=2U
Mt22tx_Mnd2p_f0 t22tx/GP OE VDDIO VDDIO pfet L=0.13U W=2U
Mt22tx_Mnd2p_f1 t22tx/GP OE VDDIO VDDIO pfet L=0.13U W=2U
Mt22tx_Mnd1n_f0 t22tx/GP DIN$22 t22tx/NA VSS nfet L=0.13U W=2U
Mt22tx_Mnd1n_f1 t22tx/GP DIN$22 t22tx/NA VSS nfet L=0.13U W=2U
Mt22tx_Mnd2n_f0 t22tx/NA OE VSS VSS nfet L=0.13U W=2U
Mt22tx_Mnd2n_f1 t22tx/NA OE VSS VSS nfet L=0.13U W=2U
Mt22tx_Mnr1p_f0 t22tx/NB DIN$22 VDDIO VDDIO pfet L=0.13U W=2U
Mt22tx_Mnr1p_f1 t22tx/NB DIN$22 VDDIO VDDIO pfet L=0.13U W=2U
Mt22tx_Mnr1p_f2 t22tx/NB DIN$22 VDDIO VDDIO pfet L=0.13U W=2U
Mt22tx_Mnr1p_f3 t22tx/NB DIN$22 VDDIO VDDIO pfet L=0.13U W=2U
Mt22tx_Mnr2p_f0 t22tx/GN t22tx/OEB t22tx/NB VDDIO pfet L=0.13U W=2U
Mt22tx_Mnr2p_f1 t22tx/GN t22tx/OEB t22tx/NB VDDIO pfet L=0.13U W=2U
Mt22tx_Mnr2p_f2 t22tx/GN t22tx/OEB t22tx/NB VDDIO pfet L=0.13U W=2U
Mt22tx_Mnr2p_f3 t22tx/GN t22tx/OEB t22tx/NB VDDIO pfet L=0.13U W=2U
Mt22tx_Mnr1n_f0 t22tx/GN DIN$22 VSS VSS nfet L=0.13U W=1U
Mt22tx_Mnr1n_f1 t22tx/GN DIN$22 VSS VSS nfet L=0.13U W=1U
Mt22tx_Mnr2n_f0 t22tx/GN t22tx/OEB VSS VSS nfet L=0.13U W=1U
Mt22tx_Mnr2n_f1 t22tx/GN t22tx/OEB VSS VSS nfet L=0.13U W=1U
Mt22tx_Mp_f0 t22tx/DP t22tx/GP VDDIO VDDIO pfet L=0.13U W=1U
Mt22tx_Mp_f1 t22tx/DP t22tx/GP VDDIO VDDIO pfet L=0.13U W=1U
Mt22tx_Mp_f2 t22tx/DP t22tx/GP VDDIO VDDIO pfet L=0.13U W=1U
Mt22tx_Mp_f3 t22tx/DP t22tx/GP VDDIO VDDIO pfet L=0.13U W=1U
Mt22tx_Mp_f4 t22tx/DP t22tx/GP VDDIO VDDIO pfet L=0.13U W=1U
Mt22tx_Mp_f5 t22tx/DP t22tx/GP VDDIO VDDIO pfet L=0.13U W=1U
Mt22tx_Mp_f6 t22tx/DP t22tx/GP VDDIO VDDIO pfet L=0.13U W=1U
Mt22tx_Mp_f7 t22tx/DP t22tx/GP VDDIO VDDIO pfet L=0.13U W=1U
Mt22tx_Mp_f8 t22tx/DP t22tx/GP VDDIO VDDIO pfet L=0.13U W=1U
Mt22tx_Mp_f9 t22tx/DP t22tx/GP VDDIO VDDIO pfet L=0.13U W=1U
Mt22tx_Mp_f10 t22tx/DP t22tx/GP VDDIO VDDIO pfet L=0.13U W=1U
Mt22tx_Mp_f11 t22tx/DP t22tx/GP VDDIO VDDIO pfet L=0.13U W=1U
Mt22tx_Mp_f12 t22tx/DP t22tx/GP VDDIO VDDIO pfet L=0.13U W=1U
Mt22tx_Mp_f13 t22tx/DP t22tx/GP VDDIO VDDIO pfet L=0.13U W=1U
Mt22tx_Mp_f14 t22tx/DP t22tx/GP VDDIO VDDIO pfet L=0.13U W=1U
Mt22tx_Mp_f15 t22tx/DP t22tx/GP VDDIO VDDIO pfet L=0.13U W=1U
Mt22tx_Mp_f16 t22tx/DP t22tx/GP VDDIO VDDIO pfet L=0.13U W=1U
Mt22tx_Mp_f17 t22tx/DP t22tx/GP VDDIO VDDIO pfet L=0.13U W=1U
Mt22tx_Mp_f18 t22tx/DP t22tx/GP VDDIO VDDIO pfet L=0.13U W=1U
Mt22tx_Mp_f19 t22tx/DP t22tx/GP VDDIO VDDIO pfet L=0.13U W=1U
Mt22tx_Mp_f20 t22tx/DP t22tx/GP VDDIO VDDIO pfet L=0.13U W=1U
Mt22tx_Mp_f21 t22tx/DP t22tx/GP VDDIO VDDIO pfet L=0.13U W=1U
Mt22tx_Mp_f22 t22tx/DP t22tx/GP VDDIO VDDIO pfet L=0.13U W=1U
Mt22tx_Mp_f23 t22tx/DP t22tx/GP VDDIO VDDIO pfet L=0.13U W=1U
Mt22tx_Mp_f24 t22tx/DP t22tx/GP VDDIO VDDIO pfet L=0.13U W=1U
Mt22tx_Mp_f25 t22tx/DP t22tx/GP VDDIO VDDIO pfet L=0.13U W=1U
Mt22tx_Mp_f26 t22tx/DP t22tx/GP VDDIO VDDIO pfet L=0.13U W=1U
Mt22tx_Mp_f27 t22tx/DP t22tx/GP VDDIO VDDIO pfet L=0.13U W=1U
Mt22tx_Mp_f28 t22tx/DP t22tx/GP VDDIO VDDIO pfet L=0.13U W=1U
Mt22tx_Mp_f29 t22tx/DP t22tx/GP VDDIO VDDIO pfet L=0.13U W=1U
Mt22tx_Mp_f30 t22tx/DP t22tx/GP VDDIO VDDIO pfet L=0.13U W=1U
Mt22tx_Mp_f31 t22tx/DP t22tx/GP VDDIO VDDIO pfet L=0.13U W=1U
Mt22tx_Mp_f32 t22tx/DP t22tx/GP VDDIO VDDIO pfet L=0.13U W=1U
Mt22tx_Mp_f33 t22tx/DP t22tx/GP VDDIO VDDIO pfet L=0.13U W=1U
Mt22tx_Mp_f34 t22tx/DP t22tx/GP VDDIO VDDIO pfet L=0.13U W=1U
Mt22tx_Mp_f35 t22tx/DP t22tx/GP VDDIO VDDIO pfet L=0.13U W=1U
Mt22tx_Mp_f36 t22tx/DP t22tx/GP VDDIO VDDIO pfet L=0.13U W=1U
Mt22tx_Mp_f37 t22tx/DP t22tx/GP VDDIO VDDIO pfet L=0.13U W=1U
Mt22tx_Mp_f38 t22tx/DP t22tx/GP VDDIO VDDIO pfet L=0.13U W=1U
Mt22tx_Mp_f39 t22tx/DP t22tx/GP VDDIO VDDIO pfet L=0.13U W=1U
Mt22tx_Mp_f40 t22tx/DP t22tx/GP VDDIO VDDIO pfet L=0.13U W=1U
Mt22tx_Mp_f41 t22tx/DP t22tx/GP VDDIO VDDIO pfet L=0.13U W=1U
Mt22tx_Mp_f42 t22tx/DP t22tx/GP VDDIO VDDIO pfet L=0.13U W=1U
Mt22tx_Mp_f43 t22tx/DP t22tx/GP VDDIO VDDIO pfet L=0.13U W=1U
Mt22tx_Mp_f44 t22tx/DP t22tx/GP VDDIO VDDIO pfet L=0.13U W=1U
Mt22tx_Mp_f45 t22tx/DP t22tx/GP VDDIO VDDIO pfet L=0.13U W=1U
Mt22tx_Mp_f46 t22tx/DP t22tx/GP VDDIO VDDIO pfet L=0.13U W=1U
Mt22tx_Mp_f47 t22tx/DP t22tx/GP VDDIO VDDIO pfet L=0.13U W=1U
Mt22tx_Mp_f48 t22tx/DP t22tx/GP VDDIO VDDIO pfet L=0.13U W=1U
Mt22tx_Mp_f49 t22tx/DP t22tx/GP VDDIO VDDIO pfet L=0.13U W=1U
Mt22tx_Mp_f50 t22tx/DP t22tx/GP VDDIO VDDIO pfet L=0.13U W=1U
Mt22tx_Mp_f51 t22tx/DP t22tx/GP VDDIO VDDIO pfet L=0.13U W=1U
Mt22tx_Mp_f52 t22tx/DP t22tx/GP VDDIO VDDIO pfet L=0.13U W=1U
Mt22tx_Mp_f53 t22tx/DP t22tx/GP VDDIO VDDIO pfet L=0.13U W=1U
Mt22tx_Mn_f0 t22tx/DN t22tx/GN VSS VSS nfet L=0.13U W=1U
Mt22tx_Mn_f1 t22tx/DN t22tx/GN VSS VSS nfet L=0.13U W=1U
Mt22tx_Mn_f2 t22tx/DN t22tx/GN VSS VSS nfet L=0.13U W=1U
Mt22tx_Mn_f3 t22tx/DN t22tx/GN VSS VSS nfet L=0.13U W=1U
Mt22tx_Mn_f4 t22tx/DN t22tx/GN VSS VSS nfet L=0.13U W=1U
Mt22tx_Mn_f5 t22tx/DN t22tx/GN VSS VSS nfet L=0.13U W=1U
Mt22tx_Mn_f6 t22tx/DN t22tx/GN VSS VSS nfet L=0.13U W=1U
Mt22tx_Mn_f7 t22tx/DN t22tx/GN VSS VSS nfet L=0.13U W=1U
Mt22tx_Mn_f8 t22tx/DN t22tx/GN VSS VSS nfet L=0.13U W=1U
Mt22tx_Mn_f9 t22tx/DN t22tx/GN VSS VSS nfet L=0.13U W=1U
Mt22tx_Mn_f10 t22tx/DN t22tx/GN VSS VSS nfet L=0.13U W=1U
Mt22tx_Mn_f11 t22tx/DN t22tx/GN VSS VSS nfet L=0.13U W=1U
Mt22tx_Mn_f12 t22tx/DN t22tx/GN VSS VSS nfet L=0.13U W=1U
Mt22tx_Mn_f13 t22tx/DN t22tx/GN VSS VSS nfet L=0.13U W=1U
Mt22tx_Mn_f14 t22tx/DN t22tx/GN VSS VSS nfet L=0.13U W=1U
Mt22tx_Mn_f15 t22tx/DN t22tx/GN VSS VSS nfet L=0.13U W=1U
Mt22tx_Mn_f16 t22tx/DN t22tx/GN VSS VSS nfet L=0.13U W=1U
Mt22tx_Mn_f17 t22tx/DN t22tx/GN VSS VSS nfet L=0.13U W=1U
Mt22tx_Mn_f18 t22tx/DN t22tx/GN VSS VSS nfet L=0.13U W=1U
Mt22tx_Mn_f19 t22tx/DN t22tx/GN VSS VSS nfet L=0.13U W=1U
Mt22tx_Mn_f20 t22tx/DN t22tx/GN VSS VSS nfet L=0.13U W=1U
Mt22tx_Mn_f21 t22tx/DN t22tx/GN VSS VSS nfet L=0.13U W=1U
Mt22tx_Mpu_f0 t22tx/PUX PUN VDDIO VDDIO pfet L=0.13U W=2U
Xt22tx_Rpu t22tx/PUX PAD$20 VSS rppd r=12472.0 L=24U W=0.5U
Mt22tx_Mpd_f0 t22tx/PDX PD VSS VSS nfet L=0.13U W=1U
Xt22tx_Rpd PAD$20 t22tx/PDX VSS rppd r=12472.0 L=24U W=0.5U
Xt22tx_Rsp t22tx/DP PAD$20 VSS rppd r=20.0 L=0.5U W=10U
Xt22tx_Rsn t22tx/DN PAD$20 VSS rppd r=20.0 L=0.5U W=10U
Dt23esd_Dp1 PAD$22 VDDIO diodevdd_mod A=35P P=58.08U
Dt23esd_Dp1_dsub VSS VDDIO dsub_2kv_mod A=224.956P P=81.12U
Mt23esd_Mn1_f0 PAD$22 VSS VSS VSS nfet L=0.13U W=2U
Mt23esd_Mn1_f1 PAD$22 VSS VSS VSS nfet L=0.13U W=2U
Mt23esd_Mn1_f2 PAD$22 VSS VSS VSS nfet L=0.13U W=2U
Mt23esd_Mn1_f3 PAD$22 VSS VSS VSS nfet L=0.13U W=2U
Mt23esd_Mn1_f4 PAD$22 VSS VSS VSS nfet L=0.13U W=2U
Mt23esd_Mn1_f5 PAD$22 VSS VSS VSS nfet L=0.13U W=2U
Mt23esd_Mn1_f6 PAD$22 VSS VSS VSS nfet L=0.13U W=2U
Mt23esd_Mn1_f7 PAD$22 VSS VSS VSS nfet L=0.13U W=2U
Mt23esd_Mn1_f8 PAD$22 VSS VSS VSS nfet L=0.13U W=2U
Mt23esd_Mn1_f9 PAD$22 VSS VSS VSS nfet L=0.13U W=2U
Mt23esd_Mclamp_f0 VDDIO VSS VSS VSS nfet L=0.35U W=2U
Mt23esd_Mclamp_f1 VDDIO VSS VSS VSS nfet L=0.35U W=2U
Mt23esd_Mclamp_f2 VDDIO VSS VSS VSS nfet L=0.35U W=2U
Mt23esd_Mclamp_f3 VDDIO VSS VSS VSS nfet L=0.35U W=2U
Mt23esd_Mclamp_f4 VDDIO VSS VSS VSS nfet L=0.35U W=2U
Mt23esd_Mclamp_f5 VDDIO VSS VSS VSS nfet L=0.35U W=2U
Mt23esd_Mclamp_f6 VDDIO VSS VSS VSS nfet L=0.35U W=2U
Mt23esd_Mclamp_f7 VDDIO VSS VSS VSS nfet L=0.35U W=2U
Mt23esd_Mclamp_f8 VDDIO VSS VSS VSS nfet L=0.35U W=2U
Mt23esd_Mclamp_f9 VDDIO VSS VSS VSS nfet L=0.35U W=2U
Mt23esd_Mclamp_f10 VDDIO VSS VSS VSS nfet L=0.35U W=2U
Mt23esd_Mclamp_f11 VDDIO VSS VSS VSS nfet L=0.35U W=2U
Mt23esd_Mclamp_f12 VDDIO VSS VSS VSS nfet L=0.35U W=2U
Mt23esd_Mclamp_f13 VDDIO VSS VSS VSS nfet L=0.35U W=2U
Mt23esd_Mclamp_f14 VDDIO VSS VSS VSS nfet L=0.35U W=2U
Mt23esd_Mclamp_f15 VDDIO VSS VSS VSS nfet L=0.35U W=2U
Mt23esd_Mclamp_f16 VDDIO VSS VSS VSS nfet L=0.35U W=2U
Mt23esd_Mclamp_f17 VDDIO VSS VSS VSS nfet L=0.35U W=2U
Mt23esd_Mclamp_f18 VDDIO VSS VSS VSS nfet L=0.35U W=2U
Mt23esd_Mclamp_f19 VDDIO VSS VSS VSS nfet L=0.35U W=2U
Xt23esd_Resd PAD$22 PADI_T23 VSS rppd r=164.6 L=1U W=2U
Dt23esd_Dp2 PADI_T23 VDDIO dpantenna A=4P P=8U
Mt23esd_Mn2_f0 PADI_T23 VSS VSS VSS nfet L=0.13U W=1U
Mt23tx_Mi1p_f0 t23tx/OEB OE VDDIO VDDIO pfet L=0.13U W=2U
Mt23tx_Mi1n_f0 t23tx/OEB OE VSS VSS nfet L=0.13U W=1U
Mt23tx_Mnd1p_f0 t23tx/GP DIN$23 VDDIO VDDIO pfet L=0.13U W=2U
Mt23tx_Mnd1p_f1 t23tx/GP DIN$23 VDDIO VDDIO pfet L=0.13U W=2U
Mt23tx_Mnd2p_f0 t23tx/GP OE VDDIO VDDIO pfet L=0.13U W=2U
Mt23tx_Mnd2p_f1 t23tx/GP OE VDDIO VDDIO pfet L=0.13U W=2U
Mt23tx_Mnd1n_f0 t23tx/GP DIN$23 t23tx/NA VSS nfet L=0.13U W=2U
Mt23tx_Mnd1n_f1 t23tx/GP DIN$23 t23tx/NA VSS nfet L=0.13U W=2U
Mt23tx_Mnd2n_f0 t23tx/NA OE VSS VSS nfet L=0.13U W=2U
Mt23tx_Mnd2n_f1 t23tx/NA OE VSS VSS nfet L=0.13U W=2U
Mt23tx_Mnr1p_f0 t23tx/NB DIN$23 VDDIO VDDIO pfet L=0.13U W=2U
Mt23tx_Mnr1p_f1 t23tx/NB DIN$23 VDDIO VDDIO pfet L=0.13U W=2U
Mt23tx_Mnr1p_f2 t23tx/NB DIN$23 VDDIO VDDIO pfet L=0.13U W=2U
Mt23tx_Mnr1p_f3 t23tx/NB DIN$23 VDDIO VDDIO pfet L=0.13U W=2U
Mt23tx_Mnr2p_f0 t23tx/GN t23tx/OEB t23tx/NB VDDIO pfet L=0.13U W=2U
Mt23tx_Mnr2p_f1 t23tx/GN t23tx/OEB t23tx/NB VDDIO pfet L=0.13U W=2U
Mt23tx_Mnr2p_f2 t23tx/GN t23tx/OEB t23tx/NB VDDIO pfet L=0.13U W=2U
Mt23tx_Mnr2p_f3 t23tx/GN t23tx/OEB t23tx/NB VDDIO pfet L=0.13U W=2U
Mt23tx_Mnr1n_f0 t23tx/GN DIN$23 VSS VSS nfet L=0.13U W=1U
Mt23tx_Mnr1n_f1 t23tx/GN DIN$23 VSS VSS nfet L=0.13U W=1U
Mt23tx_Mnr2n_f0 t23tx/GN t23tx/OEB VSS VSS nfet L=0.13U W=1U
Mt23tx_Mnr2n_f1 t23tx/GN t23tx/OEB VSS VSS nfet L=0.13U W=1U
Mt23tx_Mp_f0 t23tx/DP t23tx/GP VDDIO VDDIO pfet L=0.13U W=1U
Mt23tx_Mp_f1 t23tx/DP t23tx/GP VDDIO VDDIO pfet L=0.13U W=1U
Mt23tx_Mp_f2 t23tx/DP t23tx/GP VDDIO VDDIO pfet L=0.13U W=1U
Mt23tx_Mp_f3 t23tx/DP t23tx/GP VDDIO VDDIO pfet L=0.13U W=1U
Mt23tx_Mp_f4 t23tx/DP t23tx/GP VDDIO VDDIO pfet L=0.13U W=1U
Mt23tx_Mp_f5 t23tx/DP t23tx/GP VDDIO VDDIO pfet L=0.13U W=1U
Mt23tx_Mp_f6 t23tx/DP t23tx/GP VDDIO VDDIO pfet L=0.13U W=1U
Mt23tx_Mp_f7 t23tx/DP t23tx/GP VDDIO VDDIO pfet L=0.13U W=1U
Mt23tx_Mp_f8 t23tx/DP t23tx/GP VDDIO VDDIO pfet L=0.13U W=1U
Mt23tx_Mp_f9 t23tx/DP t23tx/GP VDDIO VDDIO pfet L=0.13U W=1U
Mt23tx_Mp_f10 t23tx/DP t23tx/GP VDDIO VDDIO pfet L=0.13U W=1U
Mt23tx_Mp_f11 t23tx/DP t23tx/GP VDDIO VDDIO pfet L=0.13U W=1U
Mt23tx_Mp_f12 t23tx/DP t23tx/GP VDDIO VDDIO pfet L=0.13U W=1U
Mt23tx_Mp_f13 t23tx/DP t23tx/GP VDDIO VDDIO pfet L=0.13U W=1U
Mt23tx_Mp_f14 t23tx/DP t23tx/GP VDDIO VDDIO pfet L=0.13U W=1U
Mt23tx_Mp_f15 t23tx/DP t23tx/GP VDDIO VDDIO pfet L=0.13U W=1U
Mt23tx_Mp_f16 t23tx/DP t23tx/GP VDDIO VDDIO pfet L=0.13U W=1U
Mt23tx_Mp_f17 t23tx/DP t23tx/GP VDDIO VDDIO pfet L=0.13U W=1U
Mt23tx_Mp_f18 t23tx/DP t23tx/GP VDDIO VDDIO pfet L=0.13U W=1U
Mt23tx_Mp_f19 t23tx/DP t23tx/GP VDDIO VDDIO pfet L=0.13U W=1U
Mt23tx_Mp_f20 t23tx/DP t23tx/GP VDDIO VDDIO pfet L=0.13U W=1U
Mt23tx_Mp_f21 t23tx/DP t23tx/GP VDDIO VDDIO pfet L=0.13U W=1U
Mt23tx_Mp_f22 t23tx/DP t23tx/GP VDDIO VDDIO pfet L=0.13U W=1U
Mt23tx_Mp_f23 t23tx/DP t23tx/GP VDDIO VDDIO pfet L=0.13U W=1U
Mt23tx_Mp_f24 t23tx/DP t23tx/GP VDDIO VDDIO pfet L=0.13U W=1U
Mt23tx_Mp_f25 t23tx/DP t23tx/GP VDDIO VDDIO pfet L=0.13U W=1U
Mt23tx_Mp_f26 t23tx/DP t23tx/GP VDDIO VDDIO pfet L=0.13U W=1U
Mt23tx_Mp_f27 t23tx/DP t23tx/GP VDDIO VDDIO pfet L=0.13U W=1U
Mt23tx_Mp_f28 t23tx/DP t23tx/GP VDDIO VDDIO pfet L=0.13U W=1U
Mt23tx_Mp_f29 t23tx/DP t23tx/GP VDDIO VDDIO pfet L=0.13U W=1U
Mt23tx_Mp_f30 t23tx/DP t23tx/GP VDDIO VDDIO pfet L=0.13U W=1U
Mt23tx_Mp_f31 t23tx/DP t23tx/GP VDDIO VDDIO pfet L=0.13U W=1U
Mt23tx_Mp_f32 t23tx/DP t23tx/GP VDDIO VDDIO pfet L=0.13U W=1U
Mt23tx_Mp_f33 t23tx/DP t23tx/GP VDDIO VDDIO pfet L=0.13U W=1U
Mt23tx_Mp_f34 t23tx/DP t23tx/GP VDDIO VDDIO pfet L=0.13U W=1U
Mt23tx_Mp_f35 t23tx/DP t23tx/GP VDDIO VDDIO pfet L=0.13U W=1U
Mt23tx_Mp_f36 t23tx/DP t23tx/GP VDDIO VDDIO pfet L=0.13U W=1U
Mt23tx_Mp_f37 t23tx/DP t23tx/GP VDDIO VDDIO pfet L=0.13U W=1U
Mt23tx_Mp_f38 t23tx/DP t23tx/GP VDDIO VDDIO pfet L=0.13U W=1U
Mt23tx_Mp_f39 t23tx/DP t23tx/GP VDDIO VDDIO pfet L=0.13U W=1U
Mt23tx_Mp_f40 t23tx/DP t23tx/GP VDDIO VDDIO pfet L=0.13U W=1U
Mt23tx_Mp_f41 t23tx/DP t23tx/GP VDDIO VDDIO pfet L=0.13U W=1U
Mt23tx_Mp_f42 t23tx/DP t23tx/GP VDDIO VDDIO pfet L=0.13U W=1U
Mt23tx_Mp_f43 t23tx/DP t23tx/GP VDDIO VDDIO pfet L=0.13U W=1U
Mt23tx_Mp_f44 t23tx/DP t23tx/GP VDDIO VDDIO pfet L=0.13U W=1U
Mt23tx_Mp_f45 t23tx/DP t23tx/GP VDDIO VDDIO pfet L=0.13U W=1U
Mt23tx_Mp_f46 t23tx/DP t23tx/GP VDDIO VDDIO pfet L=0.13U W=1U
Mt23tx_Mp_f47 t23tx/DP t23tx/GP VDDIO VDDIO pfet L=0.13U W=1U
Mt23tx_Mp_f48 t23tx/DP t23tx/GP VDDIO VDDIO pfet L=0.13U W=1U
Mt23tx_Mp_f49 t23tx/DP t23tx/GP VDDIO VDDIO pfet L=0.13U W=1U
Mt23tx_Mp_f50 t23tx/DP t23tx/GP VDDIO VDDIO pfet L=0.13U W=1U
Mt23tx_Mp_f51 t23tx/DP t23tx/GP VDDIO VDDIO pfet L=0.13U W=1U
Mt23tx_Mp_f52 t23tx/DP t23tx/GP VDDIO VDDIO pfet L=0.13U W=1U
Mt23tx_Mp_f53 t23tx/DP t23tx/GP VDDIO VDDIO pfet L=0.13U W=1U
Mt23tx_Mn_f0 t23tx/DN t23tx/GN VSS VSS nfet L=0.13U W=1U
Mt23tx_Mn_f1 t23tx/DN t23tx/GN VSS VSS nfet L=0.13U W=1U
Mt23tx_Mn_f2 t23tx/DN t23tx/GN VSS VSS nfet L=0.13U W=1U
Mt23tx_Mn_f3 t23tx/DN t23tx/GN VSS VSS nfet L=0.13U W=1U
Mt23tx_Mn_f4 t23tx/DN t23tx/GN VSS VSS nfet L=0.13U W=1U
Mt23tx_Mn_f5 t23tx/DN t23tx/GN VSS VSS nfet L=0.13U W=1U
Mt23tx_Mn_f6 t23tx/DN t23tx/GN VSS VSS nfet L=0.13U W=1U
Mt23tx_Mn_f7 t23tx/DN t23tx/GN VSS VSS nfet L=0.13U W=1U
Mt23tx_Mn_f8 t23tx/DN t23tx/GN VSS VSS nfet L=0.13U W=1U
Mt23tx_Mn_f9 t23tx/DN t23tx/GN VSS VSS nfet L=0.13U W=1U
Mt23tx_Mn_f10 t23tx/DN t23tx/GN VSS VSS nfet L=0.13U W=1U
Mt23tx_Mn_f11 t23tx/DN t23tx/GN VSS VSS nfet L=0.13U W=1U
Mt23tx_Mn_f12 t23tx/DN t23tx/GN VSS VSS nfet L=0.13U W=1U
Mt23tx_Mn_f13 t23tx/DN t23tx/GN VSS VSS nfet L=0.13U W=1U
Mt23tx_Mn_f14 t23tx/DN t23tx/GN VSS VSS nfet L=0.13U W=1U
Mt23tx_Mn_f15 t23tx/DN t23tx/GN VSS VSS nfet L=0.13U W=1U
Mt23tx_Mn_f16 t23tx/DN t23tx/GN VSS VSS nfet L=0.13U W=1U
Mt23tx_Mn_f17 t23tx/DN t23tx/GN VSS VSS nfet L=0.13U W=1U
Mt23tx_Mn_f18 t23tx/DN t23tx/GN VSS VSS nfet L=0.13U W=1U
Mt23tx_Mn_f19 t23tx/DN t23tx/GN VSS VSS nfet L=0.13U W=1U
Mt23tx_Mn_f20 t23tx/DN t23tx/GN VSS VSS nfet L=0.13U W=1U
Mt23tx_Mn_f21 t23tx/DN t23tx/GN VSS VSS nfet L=0.13U W=1U
Mt23tx_Mpu_f0 t23tx/PUX PUN VDDIO VDDIO pfet L=0.13U W=2U
Xt23tx_Rpu t23tx/PUX PAD$22 VSS rppd r=12472.0 L=24U W=0.5U
Mt23tx_Mpd_f0 t23tx/PDX PD VSS VSS nfet L=0.13U W=1U
Xt23tx_Rpd PAD$22 t23tx/PDX VSS rppd r=12472.0 L=24U W=0.5U
Xt23tx_Rsp t23tx/DP PAD$22 VSS rppd r=20.0 L=0.5U W=10U
Xt23tx_Rsn t23tx/DN PAD$22 VSS rppd r=20.0 L=0.5U W=10U
Dr0esd_Dp1 PAD$24 VDDIO diodevdd_mod A=35P P=58.08U
Dr0esd_Dp1_dsub VSS VDDIO dsub_2kv_mod A=224.956P P=81.12U
Mr0esd_Mn1_f0 PAD$24 VSS VSS VSS nfet L=0.13U W=2U
Mr0esd_Mn1_f1 PAD$24 VSS VSS VSS nfet L=0.13U W=2U
Mr0esd_Mn1_f2 PAD$24 VSS VSS VSS nfet L=0.13U W=2U
Mr0esd_Mn1_f3 PAD$24 VSS VSS VSS nfet L=0.13U W=2U
Mr0esd_Mn1_f4 PAD$24 VSS VSS VSS nfet L=0.13U W=2U
Mr0esd_Mn1_f5 PAD$24 VSS VSS VSS nfet L=0.13U W=2U
Mr0esd_Mn1_f6 PAD$24 VSS VSS VSS nfet L=0.13U W=2U
Mr0esd_Mn1_f7 PAD$24 VSS VSS VSS nfet L=0.13U W=2U
Mr0esd_Mn1_f8 PAD$24 VSS VSS VSS nfet L=0.13U W=2U
Mr0esd_Mn1_f9 PAD$24 VSS VSS VSS nfet L=0.13U W=2U
Mr0esd_Mclamp_f0 VDDIO VSS VSS VSS nfet L=0.35U W=2U
Mr0esd_Mclamp_f1 VDDIO VSS VSS VSS nfet L=0.35U W=2U
Mr0esd_Mclamp_f2 VDDIO VSS VSS VSS nfet L=0.35U W=2U
Mr0esd_Mclamp_f3 VDDIO VSS VSS VSS nfet L=0.35U W=2U
Mr0esd_Mclamp_f4 VDDIO VSS VSS VSS nfet L=0.35U W=2U
Mr0esd_Mclamp_f5 VDDIO VSS VSS VSS nfet L=0.35U W=2U
Mr0esd_Mclamp_f6 VDDIO VSS VSS VSS nfet L=0.35U W=2U
Mr0esd_Mclamp_f7 VDDIO VSS VSS VSS nfet L=0.35U W=2U
Mr0esd_Mclamp_f8 VDDIO VSS VSS VSS nfet L=0.35U W=2U
Mr0esd_Mclamp_f9 VDDIO VSS VSS VSS nfet L=0.35U W=2U
Mr0esd_Mclamp_f10 VDDIO VSS VSS VSS nfet L=0.35U W=2U
Mr0esd_Mclamp_f11 VDDIO VSS VSS VSS nfet L=0.35U W=2U
Mr0esd_Mclamp_f12 VDDIO VSS VSS VSS nfet L=0.35U W=2U
Mr0esd_Mclamp_f13 VDDIO VSS VSS VSS nfet L=0.35U W=2U
Mr0esd_Mclamp_f14 VDDIO VSS VSS VSS nfet L=0.35U W=2U
Mr0esd_Mclamp_f15 VDDIO VSS VSS VSS nfet L=0.35U W=2U
Mr0esd_Mclamp_f16 VDDIO VSS VSS VSS nfet L=0.35U W=2U
Mr0esd_Mclamp_f17 VDDIO VSS VSS VSS nfet L=0.35U W=2U
Mr0esd_Mclamp_f18 VDDIO VSS VSS VSS nfet L=0.35U W=2U
Mr0esd_Mclamp_f19 VDDIO VSS VSS VSS nfet L=0.35U W=2U
Xr0esd_Resd PAD$24 PADI_R0 VSS rppd r=164.6 L=1U W=2U
Dr0esd_Dp2 PADI_R0 VDDIO dpantenna A=4P P=8U
Mr0esd_Mn2_f0 PADI_R0 VSS VSS VSS nfet L=0.13U W=1U
Xr0rx_Rdiv1 VDDIO r0rx/vrn VSS rppd r=24804.0 L=48U W=0.5U
Xr0rx_Rdiv2 r0rx/vrn VSS VSS rppd r=24804.0 L=48U W=0.5U
Mr0rx_Mtail_f0 r0rx/s1 VDDIO VSS VSS nfet L=0.5U W=1U
Mr0rx_Mtail_f1 r0rx/s1 VDDIO VSS VSS nfet L=0.5U W=1U
Mr0rx_Mnp_f0 r0rx/d1 PADI_R0 r0rx/s1 VSS nfet L=0.5U W=0.5U
Mr0rx_Mnp_f1 r0rx/d1 PADI_R0 r0rx/s1 VSS nfet L=0.5U W=0.5U
Mr0rx_Mnn_f0 r0rx/d2 r0rx/vrn r0rx/s1 VSS nfet L=0.5U W=0.5U
Mr0rx_Mnn_f1 r0rx/d2 r0rx/vrn r0rx/s1 VSS nfet L=0.5U W=0.5U
Mr0rx_Mlp_f0 r0rx/d2 r0rx/d2 VDDIO VDDIO pfet L=0.25U W=1U
Mr0rx_Mlp_f1 r0rx/d2 r0rx/d2 VDDIO VDDIO pfet L=0.25U W=1U
Mr0rx_Mlp_f2 r0rx/d2 r0rx/d2 VDDIO VDDIO pfet L=0.25U W=1U
Mr0rx_Mlp_f3 r0rx/d2 r0rx/d2 VDDIO VDDIO pfet L=0.25U W=1U
Mr0rx_Mln_f0 r0rx/d1 r0rx/d2 VDDIO VDDIO pfet L=0.25U W=1U
Mr0rx_Mln_f1 r0rx/d1 r0rx/d2 VDDIO VDDIO pfet L=0.25U W=1U
Mr0rx_Mln_f2 r0rx/d1 r0rx/d2 VDDIO VDDIO pfet L=0.25U W=1U
Mr0rx_Mln_f3 r0rx/d1 r0rx/d2 VDDIO VDDIO pfet L=0.25U W=1U
Mr0rx_Mi2p_f0 DOUT r0rx/d1 VDDIO VDDIO pfet L=0.13U W=2U
Mr0rx_Mi2n_f0 DOUT r0rx/d1 VSS VSS nfet L=0.13U W=1U
Dr1esd_Dp1 PAD$26 VDDIO diodevdd_mod A=35P P=58.08U
Dr1esd_Dp1_dsub VSS VDDIO dsub_2kv_mod A=224.956P P=81.12U
Mr1esd_Mn1_f0 PAD$26 VSS VSS VSS nfet L=0.13U W=2U
Mr1esd_Mn1_f1 PAD$26 VSS VSS VSS nfet L=0.13U W=2U
Mr1esd_Mn1_f2 PAD$26 VSS VSS VSS nfet L=0.13U W=2U
Mr1esd_Mn1_f3 PAD$26 VSS VSS VSS nfet L=0.13U W=2U
Mr1esd_Mn1_f4 PAD$26 VSS VSS VSS nfet L=0.13U W=2U
Mr1esd_Mn1_f5 PAD$26 VSS VSS VSS nfet L=0.13U W=2U
Mr1esd_Mn1_f6 PAD$26 VSS VSS VSS nfet L=0.13U W=2U
Mr1esd_Mn1_f7 PAD$26 VSS VSS VSS nfet L=0.13U W=2U
Mr1esd_Mn1_f8 PAD$26 VSS VSS VSS nfet L=0.13U W=2U
Mr1esd_Mn1_f9 PAD$26 VSS VSS VSS nfet L=0.13U W=2U
Mr1esd_Mclamp_f0 VDDIO VSS VSS VSS nfet L=0.35U W=2U
Mr1esd_Mclamp_f1 VDDIO VSS VSS VSS nfet L=0.35U W=2U
Mr1esd_Mclamp_f2 VDDIO VSS VSS VSS nfet L=0.35U W=2U
Mr1esd_Mclamp_f3 VDDIO VSS VSS VSS nfet L=0.35U W=2U
Mr1esd_Mclamp_f4 VDDIO VSS VSS VSS nfet L=0.35U W=2U
Mr1esd_Mclamp_f5 VDDIO VSS VSS VSS nfet L=0.35U W=2U
Mr1esd_Mclamp_f6 VDDIO VSS VSS VSS nfet L=0.35U W=2U
Mr1esd_Mclamp_f7 VDDIO VSS VSS VSS nfet L=0.35U W=2U
Mr1esd_Mclamp_f8 VDDIO VSS VSS VSS nfet L=0.35U W=2U
Mr1esd_Mclamp_f9 VDDIO VSS VSS VSS nfet L=0.35U W=2U
Mr1esd_Mclamp_f10 VDDIO VSS VSS VSS nfet L=0.35U W=2U
Mr1esd_Mclamp_f11 VDDIO VSS VSS VSS nfet L=0.35U W=2U
Mr1esd_Mclamp_f12 VDDIO VSS VSS VSS nfet L=0.35U W=2U
Mr1esd_Mclamp_f13 VDDIO VSS VSS VSS nfet L=0.35U W=2U
Mr1esd_Mclamp_f14 VDDIO VSS VSS VSS nfet L=0.35U W=2U
Mr1esd_Mclamp_f15 VDDIO VSS VSS VSS nfet L=0.35U W=2U
Mr1esd_Mclamp_f16 VDDIO VSS VSS VSS nfet L=0.35U W=2U
Mr1esd_Mclamp_f17 VDDIO VSS VSS VSS nfet L=0.35U W=2U
Mr1esd_Mclamp_f18 VDDIO VSS VSS VSS nfet L=0.35U W=2U
Mr1esd_Mclamp_f19 VDDIO VSS VSS VSS nfet L=0.35U W=2U
Xr1esd_Resd PAD$26 PADI_R1 VSS rppd r=164.6 L=1U W=2U
Dr1esd_Dp2 PADI_R1 VDDIO dpantenna A=4P P=8U
Mr1esd_Mn2_f0 PADI_R1 VSS VSS VSS nfet L=0.13U W=1U
Xr1rx_Rdiv1 VDDIO r1rx/vrn VSS rppd r=24804.0 L=48U W=0.5U
Xr1rx_Rdiv2 r1rx/vrn VSS VSS rppd r=24804.0 L=48U W=0.5U
Mr1rx_Mtail_f0 r1rx/s1 VDDIO VSS VSS nfet L=0.5U W=1U
Mr1rx_Mtail_f1 r1rx/s1 VDDIO VSS VSS nfet L=0.5U W=1U
Mr1rx_Mnp_f0 r1rx/d1 PADI_R1 r1rx/s1 VSS nfet L=0.5U W=0.5U
Mr1rx_Mnp_f1 r1rx/d1 PADI_R1 r1rx/s1 VSS nfet L=0.5U W=0.5U
Mr1rx_Mnn_f0 r1rx/d2 r1rx/vrn r1rx/s1 VSS nfet L=0.5U W=0.5U
Mr1rx_Mnn_f1 r1rx/d2 r1rx/vrn r1rx/s1 VSS nfet L=0.5U W=0.5U
Mr1rx_Mlp_f0 r1rx/d2 r1rx/d2 VDDIO VDDIO pfet L=0.25U W=1U
Mr1rx_Mlp_f1 r1rx/d2 r1rx/d2 VDDIO VDDIO pfet L=0.25U W=1U
Mr1rx_Mlp_f2 r1rx/d2 r1rx/d2 VDDIO VDDIO pfet L=0.25U W=1U
Mr1rx_Mlp_f3 r1rx/d2 r1rx/d2 VDDIO VDDIO pfet L=0.25U W=1U
Mr1rx_Mln_f0 r1rx/d1 r1rx/d2 VDDIO VDDIO pfet L=0.25U W=1U
Mr1rx_Mln_f1 r1rx/d1 r1rx/d2 VDDIO VDDIO pfet L=0.25U W=1U
Mr1rx_Mln_f2 r1rx/d1 r1rx/d2 VDDIO VDDIO pfet L=0.25U W=1U
Mr1rx_Mln_f3 r1rx/d1 r1rx/d2 VDDIO VDDIO pfet L=0.25U W=1U
Mr1rx_Mi2p_f0 DOUT$1 r1rx/d1 VDDIO VDDIO pfet L=0.13U W=2U
Mr1rx_Mi2n_f0 DOUT$1 r1rx/d1 VSS VSS nfet L=0.13U W=1U
Dr2esd_Dp1 PAD$27 VDDIO diodevdd_mod A=35P P=58.08U
Dr2esd_Dp1_dsub VSS VDDIO dsub_2kv_mod A=224.956P P=81.12U
Mr2esd_Mn1_f0 PAD$27 VSS VSS VSS nfet L=0.13U W=2U
Mr2esd_Mn1_f1 PAD$27 VSS VSS VSS nfet L=0.13U W=2U
Mr2esd_Mn1_f2 PAD$27 VSS VSS VSS nfet L=0.13U W=2U
Mr2esd_Mn1_f3 PAD$27 VSS VSS VSS nfet L=0.13U W=2U
Mr2esd_Mn1_f4 PAD$27 VSS VSS VSS nfet L=0.13U W=2U
Mr2esd_Mn1_f5 PAD$27 VSS VSS VSS nfet L=0.13U W=2U
Mr2esd_Mn1_f6 PAD$27 VSS VSS VSS nfet L=0.13U W=2U
Mr2esd_Mn1_f7 PAD$27 VSS VSS VSS nfet L=0.13U W=2U
Mr2esd_Mn1_f8 PAD$27 VSS VSS VSS nfet L=0.13U W=2U
Mr2esd_Mn1_f9 PAD$27 VSS VSS VSS nfet L=0.13U W=2U
Mr2esd_Mclamp_f0 VDDIO VSS VSS VSS nfet L=0.35U W=2U
Mr2esd_Mclamp_f1 VDDIO VSS VSS VSS nfet L=0.35U W=2U
Mr2esd_Mclamp_f2 VDDIO VSS VSS VSS nfet L=0.35U W=2U
Mr2esd_Mclamp_f3 VDDIO VSS VSS VSS nfet L=0.35U W=2U
Mr2esd_Mclamp_f4 VDDIO VSS VSS VSS nfet L=0.35U W=2U
Mr2esd_Mclamp_f5 VDDIO VSS VSS VSS nfet L=0.35U W=2U
Mr2esd_Mclamp_f6 VDDIO VSS VSS VSS nfet L=0.35U W=2U
Mr2esd_Mclamp_f7 VDDIO VSS VSS VSS nfet L=0.35U W=2U
Mr2esd_Mclamp_f8 VDDIO VSS VSS VSS nfet L=0.35U W=2U
Mr2esd_Mclamp_f9 VDDIO VSS VSS VSS nfet L=0.35U W=2U
Mr2esd_Mclamp_f10 VDDIO VSS VSS VSS nfet L=0.35U W=2U
Mr2esd_Mclamp_f11 VDDIO VSS VSS VSS nfet L=0.35U W=2U
Mr2esd_Mclamp_f12 VDDIO VSS VSS VSS nfet L=0.35U W=2U
Mr2esd_Mclamp_f13 VDDIO VSS VSS VSS nfet L=0.35U W=2U
Mr2esd_Mclamp_f14 VDDIO VSS VSS VSS nfet L=0.35U W=2U
Mr2esd_Mclamp_f15 VDDIO VSS VSS VSS nfet L=0.35U W=2U
Mr2esd_Mclamp_f16 VDDIO VSS VSS VSS nfet L=0.35U W=2U
Mr2esd_Mclamp_f17 VDDIO VSS VSS VSS nfet L=0.35U W=2U
Mr2esd_Mclamp_f18 VDDIO VSS VSS VSS nfet L=0.35U W=2U
Mr2esd_Mclamp_f19 VDDIO VSS VSS VSS nfet L=0.35U W=2U
Xr2esd_Resd PAD$27 PADI_R2 VSS rppd r=164.6 L=1U W=2U
Dr2esd_Dp2 PADI_R2 VDDIO dpantenna A=4P P=8U
Mr2esd_Mn2_f0 PADI_R2 VSS VSS VSS nfet L=0.13U W=1U
Xr2rx_Rdiv1 VDDIO r2rx/vrn VSS rppd r=24804.0 L=48U W=0.5U
Xr2rx_Rdiv2 r2rx/vrn VSS VSS rppd r=24804.0 L=48U W=0.5U
Mr2rx_Mtail_f0 r2rx/s1 VDDIO VSS VSS nfet L=0.5U W=1U
Mr2rx_Mtail_f1 r2rx/s1 VDDIO VSS VSS nfet L=0.5U W=1U
Mr2rx_Mnp_f0 r2rx/d1 PADI_R2 r2rx/s1 VSS nfet L=0.5U W=0.5U
Mr2rx_Mnp_f1 r2rx/d1 PADI_R2 r2rx/s1 VSS nfet L=0.5U W=0.5U
Mr2rx_Mnn_f0 r2rx/d2 r2rx/vrn r2rx/s1 VSS nfet L=0.5U W=0.5U
Mr2rx_Mnn_f1 r2rx/d2 r2rx/vrn r2rx/s1 VSS nfet L=0.5U W=0.5U
Mr2rx_Mlp_f0 r2rx/d2 r2rx/d2 VDDIO VDDIO pfet L=0.25U W=1U
Mr2rx_Mlp_f1 r2rx/d2 r2rx/d2 VDDIO VDDIO pfet L=0.25U W=1U
Mr2rx_Mlp_f2 r2rx/d2 r2rx/d2 VDDIO VDDIO pfet L=0.25U W=1U
Mr2rx_Mlp_f3 r2rx/d2 r2rx/d2 VDDIO VDDIO pfet L=0.25U W=1U
Mr2rx_Mln_f0 r2rx/d1 r2rx/d2 VDDIO VDDIO pfet L=0.25U W=1U
Mr2rx_Mln_f1 r2rx/d1 r2rx/d2 VDDIO VDDIO pfet L=0.25U W=1U
Mr2rx_Mln_f2 r2rx/d1 r2rx/d2 VDDIO VDDIO pfet L=0.25U W=1U
Mr2rx_Mln_f3 r2rx/d1 r2rx/d2 VDDIO VDDIO pfet L=0.25U W=1U
Mr2rx_Mi2p_f0 DOUT$2 r2rx/d1 VDDIO VDDIO pfet L=0.13U W=2U
Mr2rx_Mi2n_f0 DOUT$2 r2rx/d1 VSS VSS nfet L=0.13U W=1U
Dr3esd_Dp1 PAD$28 VDDIO diodevdd_mod A=35P P=58.08U
Dr3esd_Dp1_dsub VSS VDDIO dsub_2kv_mod A=224.956P P=81.12U
Mr3esd_Mn1_f0 PAD$28 VSS VSS VSS nfet L=0.13U W=2U
Mr3esd_Mn1_f1 PAD$28 VSS VSS VSS nfet L=0.13U W=2U
Mr3esd_Mn1_f2 PAD$28 VSS VSS VSS nfet L=0.13U W=2U
Mr3esd_Mn1_f3 PAD$28 VSS VSS VSS nfet L=0.13U W=2U
Mr3esd_Mn1_f4 PAD$28 VSS VSS VSS nfet L=0.13U W=2U
Mr3esd_Mn1_f5 PAD$28 VSS VSS VSS nfet L=0.13U W=2U
Mr3esd_Mn1_f6 PAD$28 VSS VSS VSS nfet L=0.13U W=2U
Mr3esd_Mn1_f7 PAD$28 VSS VSS VSS nfet L=0.13U W=2U
Mr3esd_Mn1_f8 PAD$28 VSS VSS VSS nfet L=0.13U W=2U
Mr3esd_Mn1_f9 PAD$28 VSS VSS VSS nfet L=0.13U W=2U
Mr3esd_Mclamp_f0 VDDIO VSS VSS VSS nfet L=0.35U W=2U
Mr3esd_Mclamp_f1 VDDIO VSS VSS VSS nfet L=0.35U W=2U
Mr3esd_Mclamp_f2 VDDIO VSS VSS VSS nfet L=0.35U W=2U
Mr3esd_Mclamp_f3 VDDIO VSS VSS VSS nfet L=0.35U W=2U
Mr3esd_Mclamp_f4 VDDIO VSS VSS VSS nfet L=0.35U W=2U
Mr3esd_Mclamp_f5 VDDIO VSS VSS VSS nfet L=0.35U W=2U
Mr3esd_Mclamp_f6 VDDIO VSS VSS VSS nfet L=0.35U W=2U
Mr3esd_Mclamp_f7 VDDIO VSS VSS VSS nfet L=0.35U W=2U
Mr3esd_Mclamp_f8 VDDIO VSS VSS VSS nfet L=0.35U W=2U
Mr3esd_Mclamp_f9 VDDIO VSS VSS VSS nfet L=0.35U W=2U
Mr3esd_Mclamp_f10 VDDIO VSS VSS VSS nfet L=0.35U W=2U
Mr3esd_Mclamp_f11 VDDIO VSS VSS VSS nfet L=0.35U W=2U
Mr3esd_Mclamp_f12 VDDIO VSS VSS VSS nfet L=0.35U W=2U
Mr3esd_Mclamp_f13 VDDIO VSS VSS VSS nfet L=0.35U W=2U
Mr3esd_Mclamp_f14 VDDIO VSS VSS VSS nfet L=0.35U W=2U
Mr3esd_Mclamp_f15 VDDIO VSS VSS VSS nfet L=0.35U W=2U
Mr3esd_Mclamp_f16 VDDIO VSS VSS VSS nfet L=0.35U W=2U
Mr3esd_Mclamp_f17 VDDIO VSS VSS VSS nfet L=0.35U W=2U
Mr3esd_Mclamp_f18 VDDIO VSS VSS VSS nfet L=0.35U W=2U
Mr3esd_Mclamp_f19 VDDIO VSS VSS VSS nfet L=0.35U W=2U
Xr3esd_Resd PAD$28 PADI_R3 VSS rppd r=164.6 L=1U W=2U
Dr3esd_Dp2 PADI_R3 VDDIO dpantenna A=4P P=8U
Mr3esd_Mn2_f0 PADI_R3 VSS VSS VSS nfet L=0.13U W=1U
Xr3rx_Rdiv1 VDDIO r3rx/vrn VSS rppd r=24804.0 L=48U W=0.5U
Xr3rx_Rdiv2 r3rx/vrn VSS VSS rppd r=24804.0 L=48U W=0.5U
Mr3rx_Mtail_f0 r3rx/s1 VDDIO VSS VSS nfet L=0.5U W=1U
Mr3rx_Mtail_f1 r3rx/s1 VDDIO VSS VSS nfet L=0.5U W=1U
Mr3rx_Mnp_f0 r3rx/d1 PADI_R3 r3rx/s1 VSS nfet L=0.5U W=0.5U
Mr3rx_Mnp_f1 r3rx/d1 PADI_R3 r3rx/s1 VSS nfet L=0.5U W=0.5U
Mr3rx_Mnn_f0 r3rx/d2 r3rx/vrn r3rx/s1 VSS nfet L=0.5U W=0.5U
Mr3rx_Mnn_f1 r3rx/d2 r3rx/vrn r3rx/s1 VSS nfet L=0.5U W=0.5U
Mr3rx_Mlp_f0 r3rx/d2 r3rx/d2 VDDIO VDDIO pfet L=0.25U W=1U
Mr3rx_Mlp_f1 r3rx/d2 r3rx/d2 VDDIO VDDIO pfet L=0.25U W=1U
Mr3rx_Mlp_f2 r3rx/d2 r3rx/d2 VDDIO VDDIO pfet L=0.25U W=1U
Mr3rx_Mlp_f3 r3rx/d2 r3rx/d2 VDDIO VDDIO pfet L=0.25U W=1U
Mr3rx_Mln_f0 r3rx/d1 r3rx/d2 VDDIO VDDIO pfet L=0.25U W=1U
Mr3rx_Mln_f1 r3rx/d1 r3rx/d2 VDDIO VDDIO pfet L=0.25U W=1U
Mr3rx_Mln_f2 r3rx/d1 r3rx/d2 VDDIO VDDIO pfet L=0.25U W=1U
Mr3rx_Mln_f3 r3rx/d1 r3rx/d2 VDDIO VDDIO pfet L=0.25U W=1U
Mr3rx_Mi2p_f0 DOUT$3 r3rx/d1 VDDIO VDDIO pfet L=0.13U W=2U
Mr3rx_Mi2n_f0 DOUT$3 r3rx/d1 VSS VSS nfet L=0.13U W=1U
Dr4esd_Dp1 PAD$29 VDDIO diodevdd_mod A=35P P=58.08U
Dr4esd_Dp1_dsub VSS VDDIO dsub_2kv_mod A=224.956P P=81.12U
Mr4esd_Mn1_f0 PAD$29 VSS VSS VSS nfet L=0.13U W=2U
Mr4esd_Mn1_f1 PAD$29 VSS VSS VSS nfet L=0.13U W=2U
Mr4esd_Mn1_f2 PAD$29 VSS VSS VSS nfet L=0.13U W=2U
Mr4esd_Mn1_f3 PAD$29 VSS VSS VSS nfet L=0.13U W=2U
Mr4esd_Mn1_f4 PAD$29 VSS VSS VSS nfet L=0.13U W=2U
Mr4esd_Mn1_f5 PAD$29 VSS VSS VSS nfet L=0.13U W=2U
Mr4esd_Mn1_f6 PAD$29 VSS VSS VSS nfet L=0.13U W=2U
Mr4esd_Mn1_f7 PAD$29 VSS VSS VSS nfet L=0.13U W=2U
Mr4esd_Mn1_f8 PAD$29 VSS VSS VSS nfet L=0.13U W=2U
Mr4esd_Mn1_f9 PAD$29 VSS VSS VSS nfet L=0.13U W=2U
Mr4esd_Mclamp_f0 VDDIO VSS VSS VSS nfet L=0.35U W=2U
Mr4esd_Mclamp_f1 VDDIO VSS VSS VSS nfet L=0.35U W=2U
Mr4esd_Mclamp_f2 VDDIO VSS VSS VSS nfet L=0.35U W=2U
Mr4esd_Mclamp_f3 VDDIO VSS VSS VSS nfet L=0.35U W=2U
Mr4esd_Mclamp_f4 VDDIO VSS VSS VSS nfet L=0.35U W=2U
Mr4esd_Mclamp_f5 VDDIO VSS VSS VSS nfet L=0.35U W=2U
Mr4esd_Mclamp_f6 VDDIO VSS VSS VSS nfet L=0.35U W=2U
Mr4esd_Mclamp_f7 VDDIO VSS VSS VSS nfet L=0.35U W=2U
Mr4esd_Mclamp_f8 VDDIO VSS VSS VSS nfet L=0.35U W=2U
Mr4esd_Mclamp_f9 VDDIO VSS VSS VSS nfet L=0.35U W=2U
Mr4esd_Mclamp_f10 VDDIO VSS VSS VSS nfet L=0.35U W=2U
Mr4esd_Mclamp_f11 VDDIO VSS VSS VSS nfet L=0.35U W=2U
Mr4esd_Mclamp_f12 VDDIO VSS VSS VSS nfet L=0.35U W=2U
Mr4esd_Mclamp_f13 VDDIO VSS VSS VSS nfet L=0.35U W=2U
Mr4esd_Mclamp_f14 VDDIO VSS VSS VSS nfet L=0.35U W=2U
Mr4esd_Mclamp_f15 VDDIO VSS VSS VSS nfet L=0.35U W=2U
Mr4esd_Mclamp_f16 VDDIO VSS VSS VSS nfet L=0.35U W=2U
Mr4esd_Mclamp_f17 VDDIO VSS VSS VSS nfet L=0.35U W=2U
Mr4esd_Mclamp_f18 VDDIO VSS VSS VSS nfet L=0.35U W=2U
Mr4esd_Mclamp_f19 VDDIO VSS VSS VSS nfet L=0.35U W=2U
Xr4esd_Resd PAD$29 PADI_R4 VSS rppd r=164.6 L=1U W=2U
Dr4esd_Dp2 PADI_R4 VDDIO dpantenna A=4P P=8U
Mr4esd_Mn2_f0 PADI_R4 VSS VSS VSS nfet L=0.13U W=1U
Xr4rx_Rdiv1 VDDIO r4rx/vrn VSS rppd r=24804.0 L=48U W=0.5U
Xr4rx_Rdiv2 r4rx/vrn VSS VSS rppd r=24804.0 L=48U W=0.5U
Mr4rx_Mtail_f0 r4rx/s1 VDDIO VSS VSS nfet L=0.5U W=1U
Mr4rx_Mtail_f1 r4rx/s1 VDDIO VSS VSS nfet L=0.5U W=1U
Mr4rx_Mnp_f0 r4rx/d1 PADI_R4 r4rx/s1 VSS nfet L=0.5U W=0.5U
Mr4rx_Mnp_f1 r4rx/d1 PADI_R4 r4rx/s1 VSS nfet L=0.5U W=0.5U
Mr4rx_Mnn_f0 r4rx/d2 r4rx/vrn r4rx/s1 VSS nfet L=0.5U W=0.5U
Mr4rx_Mnn_f1 r4rx/d2 r4rx/vrn r4rx/s1 VSS nfet L=0.5U W=0.5U
Mr4rx_Mlp_f0 r4rx/d2 r4rx/d2 VDDIO VDDIO pfet L=0.25U W=1U
Mr4rx_Mlp_f1 r4rx/d2 r4rx/d2 VDDIO VDDIO pfet L=0.25U W=1U
Mr4rx_Mlp_f2 r4rx/d2 r4rx/d2 VDDIO VDDIO pfet L=0.25U W=1U
Mr4rx_Mlp_f3 r4rx/d2 r4rx/d2 VDDIO VDDIO pfet L=0.25U W=1U
Mr4rx_Mln_f0 r4rx/d1 r4rx/d2 VDDIO VDDIO pfet L=0.25U W=1U
Mr4rx_Mln_f1 r4rx/d1 r4rx/d2 VDDIO VDDIO pfet L=0.25U W=1U
Mr4rx_Mln_f2 r4rx/d1 r4rx/d2 VDDIO VDDIO pfet L=0.25U W=1U
Mr4rx_Mln_f3 r4rx/d1 r4rx/d2 VDDIO VDDIO pfet L=0.25U W=1U
Mr4rx_Mi2p_f0 DOUT$4 r4rx/d1 VDDIO VDDIO pfet L=0.13U W=2U
Mr4rx_Mi2n_f0 DOUT$4 r4rx/d1 VSS VSS nfet L=0.13U W=1U
Dr5esd_Dp1 PAD$31 VDDIO diodevdd_mod A=35P P=58.08U
Dr5esd_Dp1_dsub VSS VDDIO dsub_2kv_mod A=224.956P P=81.12U
Mr5esd_Mn1_f0 PAD$31 VSS VSS VSS nfet L=0.13U W=2U
Mr5esd_Mn1_f1 PAD$31 VSS VSS VSS nfet L=0.13U W=2U
Mr5esd_Mn1_f2 PAD$31 VSS VSS VSS nfet L=0.13U W=2U
Mr5esd_Mn1_f3 PAD$31 VSS VSS VSS nfet L=0.13U W=2U
Mr5esd_Mn1_f4 PAD$31 VSS VSS VSS nfet L=0.13U W=2U
Mr5esd_Mn1_f5 PAD$31 VSS VSS VSS nfet L=0.13U W=2U
Mr5esd_Mn1_f6 PAD$31 VSS VSS VSS nfet L=0.13U W=2U
Mr5esd_Mn1_f7 PAD$31 VSS VSS VSS nfet L=0.13U W=2U
Mr5esd_Mn1_f8 PAD$31 VSS VSS VSS nfet L=0.13U W=2U
Mr5esd_Mn1_f9 PAD$31 VSS VSS VSS nfet L=0.13U W=2U
Mr5esd_Mclamp_f0 VDDIO VSS VSS VSS nfet L=0.35U W=2U
Mr5esd_Mclamp_f1 VDDIO VSS VSS VSS nfet L=0.35U W=2U
Mr5esd_Mclamp_f2 VDDIO VSS VSS VSS nfet L=0.35U W=2U
Mr5esd_Mclamp_f3 VDDIO VSS VSS VSS nfet L=0.35U W=2U
Mr5esd_Mclamp_f4 VDDIO VSS VSS VSS nfet L=0.35U W=2U
Mr5esd_Mclamp_f5 VDDIO VSS VSS VSS nfet L=0.35U W=2U
Mr5esd_Mclamp_f6 VDDIO VSS VSS VSS nfet L=0.35U W=2U
Mr5esd_Mclamp_f7 VDDIO VSS VSS VSS nfet L=0.35U W=2U
Mr5esd_Mclamp_f8 VDDIO VSS VSS VSS nfet L=0.35U W=2U
Mr5esd_Mclamp_f9 VDDIO VSS VSS VSS nfet L=0.35U W=2U
Mr5esd_Mclamp_f10 VDDIO VSS VSS VSS nfet L=0.35U W=2U
Mr5esd_Mclamp_f11 VDDIO VSS VSS VSS nfet L=0.35U W=2U
Mr5esd_Mclamp_f12 VDDIO VSS VSS VSS nfet L=0.35U W=2U
Mr5esd_Mclamp_f13 VDDIO VSS VSS VSS nfet L=0.35U W=2U
Mr5esd_Mclamp_f14 VDDIO VSS VSS VSS nfet L=0.35U W=2U
Mr5esd_Mclamp_f15 VDDIO VSS VSS VSS nfet L=0.35U W=2U
Mr5esd_Mclamp_f16 VDDIO VSS VSS VSS nfet L=0.35U W=2U
Mr5esd_Mclamp_f17 VDDIO VSS VSS VSS nfet L=0.35U W=2U
Mr5esd_Mclamp_f18 VDDIO VSS VSS VSS nfet L=0.35U W=2U
Mr5esd_Mclamp_f19 VDDIO VSS VSS VSS nfet L=0.35U W=2U
Xr5esd_Resd PAD$31 PADI_R5 VSS rppd r=164.6 L=1U W=2U
Dr5esd_Dp2 PADI_R5 VDDIO dpantenna A=4P P=8U
Mr5esd_Mn2_f0 PADI_R5 VSS VSS VSS nfet L=0.13U W=1U
Xr5rx_Rdiv1 VDDIO r5rx/vrn VSS rppd r=24804.0 L=48U W=0.5U
Xr5rx_Rdiv2 r5rx/vrn VSS VSS rppd r=24804.0 L=48U W=0.5U
Mr5rx_Mtail_f0 r5rx/s1 VDDIO VSS VSS nfet L=0.5U W=1U
Mr5rx_Mtail_f1 r5rx/s1 VDDIO VSS VSS nfet L=0.5U W=1U
Mr5rx_Mnp_f0 r5rx/d1 PADI_R5 r5rx/s1 VSS nfet L=0.5U W=0.5U
Mr5rx_Mnp_f1 r5rx/d1 PADI_R5 r5rx/s1 VSS nfet L=0.5U W=0.5U
Mr5rx_Mnn_f0 r5rx/d2 r5rx/vrn r5rx/s1 VSS nfet L=0.5U W=0.5U
Mr5rx_Mnn_f1 r5rx/d2 r5rx/vrn r5rx/s1 VSS nfet L=0.5U W=0.5U
Mr5rx_Mlp_f0 r5rx/d2 r5rx/d2 VDDIO VDDIO pfet L=0.25U W=1U
Mr5rx_Mlp_f1 r5rx/d2 r5rx/d2 VDDIO VDDIO pfet L=0.25U W=1U
Mr5rx_Mlp_f2 r5rx/d2 r5rx/d2 VDDIO VDDIO pfet L=0.25U W=1U
Mr5rx_Mlp_f3 r5rx/d2 r5rx/d2 VDDIO VDDIO pfet L=0.25U W=1U
Mr5rx_Mln_f0 r5rx/d1 r5rx/d2 VDDIO VDDIO pfet L=0.25U W=1U
Mr5rx_Mln_f1 r5rx/d1 r5rx/d2 VDDIO VDDIO pfet L=0.25U W=1U
Mr5rx_Mln_f2 r5rx/d1 r5rx/d2 VDDIO VDDIO pfet L=0.25U W=1U
Mr5rx_Mln_f3 r5rx/d1 r5rx/d2 VDDIO VDDIO pfet L=0.25U W=1U
Mr5rx_Mi2p_f0 DOUT$5 r5rx/d1 VDDIO VDDIO pfet L=0.13U W=2U
Mr5rx_Mi2n_f0 DOUT$5 r5rx/d1 VSS VSS nfet L=0.13U W=1U
Dr6esd_Dp1 PAD$32 VDDIO diodevdd_mod A=35P P=58.08U
Dr6esd_Dp1_dsub VSS VDDIO dsub_2kv_mod A=224.956P P=81.12U
Mr6esd_Mn1_f0 PAD$32 VSS VSS VSS nfet L=0.13U W=2U
Mr6esd_Mn1_f1 PAD$32 VSS VSS VSS nfet L=0.13U W=2U
Mr6esd_Mn1_f2 PAD$32 VSS VSS VSS nfet L=0.13U W=2U
Mr6esd_Mn1_f3 PAD$32 VSS VSS VSS nfet L=0.13U W=2U
Mr6esd_Mn1_f4 PAD$32 VSS VSS VSS nfet L=0.13U W=2U
Mr6esd_Mn1_f5 PAD$32 VSS VSS VSS nfet L=0.13U W=2U
Mr6esd_Mn1_f6 PAD$32 VSS VSS VSS nfet L=0.13U W=2U
Mr6esd_Mn1_f7 PAD$32 VSS VSS VSS nfet L=0.13U W=2U
Mr6esd_Mn1_f8 PAD$32 VSS VSS VSS nfet L=0.13U W=2U
Mr6esd_Mn1_f9 PAD$32 VSS VSS VSS nfet L=0.13U W=2U
Mr6esd_Mclamp_f0 VDDIO VSS VSS VSS nfet L=0.35U W=2U
Mr6esd_Mclamp_f1 VDDIO VSS VSS VSS nfet L=0.35U W=2U
Mr6esd_Mclamp_f2 VDDIO VSS VSS VSS nfet L=0.35U W=2U
Mr6esd_Mclamp_f3 VDDIO VSS VSS VSS nfet L=0.35U W=2U
Mr6esd_Mclamp_f4 VDDIO VSS VSS VSS nfet L=0.35U W=2U
Mr6esd_Mclamp_f5 VDDIO VSS VSS VSS nfet L=0.35U W=2U
Mr6esd_Mclamp_f6 VDDIO VSS VSS VSS nfet L=0.35U W=2U
Mr6esd_Mclamp_f7 VDDIO VSS VSS VSS nfet L=0.35U W=2U
Mr6esd_Mclamp_f8 VDDIO VSS VSS VSS nfet L=0.35U W=2U
Mr6esd_Mclamp_f9 VDDIO VSS VSS VSS nfet L=0.35U W=2U
Mr6esd_Mclamp_f10 VDDIO VSS VSS VSS nfet L=0.35U W=2U
Mr6esd_Mclamp_f11 VDDIO VSS VSS VSS nfet L=0.35U W=2U
Mr6esd_Mclamp_f12 VDDIO VSS VSS VSS nfet L=0.35U W=2U
Mr6esd_Mclamp_f13 VDDIO VSS VSS VSS nfet L=0.35U W=2U
Mr6esd_Mclamp_f14 VDDIO VSS VSS VSS nfet L=0.35U W=2U
Mr6esd_Mclamp_f15 VDDIO VSS VSS VSS nfet L=0.35U W=2U
Mr6esd_Mclamp_f16 VDDIO VSS VSS VSS nfet L=0.35U W=2U
Mr6esd_Mclamp_f17 VDDIO VSS VSS VSS nfet L=0.35U W=2U
Mr6esd_Mclamp_f18 VDDIO VSS VSS VSS nfet L=0.35U W=2U
Mr6esd_Mclamp_f19 VDDIO VSS VSS VSS nfet L=0.35U W=2U
Xr6esd_Resd PAD$32 PADI_R6 VSS rppd r=164.6 L=1U W=2U
Dr6esd_Dp2 PADI_R6 VDDIO dpantenna A=4P P=8U
Mr6esd_Mn2_f0 PADI_R6 VSS VSS VSS nfet L=0.13U W=1U
Xr6rx_Rdiv1 VDDIO r6rx/vrn VSS rppd r=24804.0 L=48U W=0.5U
Xr6rx_Rdiv2 r6rx/vrn VSS VSS rppd r=24804.0 L=48U W=0.5U
Mr6rx_Mtail_f0 r6rx/s1 VDDIO VSS VSS nfet L=0.5U W=1U
Mr6rx_Mtail_f1 r6rx/s1 VDDIO VSS VSS nfet L=0.5U W=1U
Mr6rx_Mnp_f0 r6rx/d1 PADI_R6 r6rx/s1 VSS nfet L=0.5U W=0.5U
Mr6rx_Mnp_f1 r6rx/d1 PADI_R6 r6rx/s1 VSS nfet L=0.5U W=0.5U
Mr6rx_Mnn_f0 r6rx/d2 r6rx/vrn r6rx/s1 VSS nfet L=0.5U W=0.5U
Mr6rx_Mnn_f1 r6rx/d2 r6rx/vrn r6rx/s1 VSS nfet L=0.5U W=0.5U
Mr6rx_Mlp_f0 r6rx/d2 r6rx/d2 VDDIO VDDIO pfet L=0.25U W=1U
Mr6rx_Mlp_f1 r6rx/d2 r6rx/d2 VDDIO VDDIO pfet L=0.25U W=1U
Mr6rx_Mlp_f2 r6rx/d2 r6rx/d2 VDDIO VDDIO pfet L=0.25U W=1U
Mr6rx_Mlp_f3 r6rx/d2 r6rx/d2 VDDIO VDDIO pfet L=0.25U W=1U
Mr6rx_Mln_f0 r6rx/d1 r6rx/d2 VDDIO VDDIO pfet L=0.25U W=1U
Mr6rx_Mln_f1 r6rx/d1 r6rx/d2 VDDIO VDDIO pfet L=0.25U W=1U
Mr6rx_Mln_f2 r6rx/d1 r6rx/d2 VDDIO VDDIO pfet L=0.25U W=1U
Mr6rx_Mln_f3 r6rx/d1 r6rx/d2 VDDIO VDDIO pfet L=0.25U W=1U
Mr6rx_Mi2p_f0 DOUT$6 r6rx/d1 VDDIO VDDIO pfet L=0.13U W=2U
Mr6rx_Mi2n_f0 DOUT$6 r6rx/d1 VSS VSS nfet L=0.13U W=1U
Dr7esd_Dp1 PAD$33 VDDIO diodevdd_mod A=35P P=58.08U
Dr7esd_Dp1_dsub VSS VDDIO dsub_2kv_mod A=224.956P P=81.12U
Mr7esd_Mn1_f0 PAD$33 VSS VSS VSS nfet L=0.13U W=2U
Mr7esd_Mn1_f1 PAD$33 VSS VSS VSS nfet L=0.13U W=2U
Mr7esd_Mn1_f2 PAD$33 VSS VSS VSS nfet L=0.13U W=2U
Mr7esd_Mn1_f3 PAD$33 VSS VSS VSS nfet L=0.13U W=2U
Mr7esd_Mn1_f4 PAD$33 VSS VSS VSS nfet L=0.13U W=2U
Mr7esd_Mn1_f5 PAD$33 VSS VSS VSS nfet L=0.13U W=2U
Mr7esd_Mn1_f6 PAD$33 VSS VSS VSS nfet L=0.13U W=2U
Mr7esd_Mn1_f7 PAD$33 VSS VSS VSS nfet L=0.13U W=2U
Mr7esd_Mn1_f8 PAD$33 VSS VSS VSS nfet L=0.13U W=2U
Mr7esd_Mn1_f9 PAD$33 VSS VSS VSS nfet L=0.13U W=2U
Mr7esd_Mclamp_f0 VDDIO VSS VSS VSS nfet L=0.35U W=2U
Mr7esd_Mclamp_f1 VDDIO VSS VSS VSS nfet L=0.35U W=2U
Mr7esd_Mclamp_f2 VDDIO VSS VSS VSS nfet L=0.35U W=2U
Mr7esd_Mclamp_f3 VDDIO VSS VSS VSS nfet L=0.35U W=2U
Mr7esd_Mclamp_f4 VDDIO VSS VSS VSS nfet L=0.35U W=2U
Mr7esd_Mclamp_f5 VDDIO VSS VSS VSS nfet L=0.35U W=2U
Mr7esd_Mclamp_f6 VDDIO VSS VSS VSS nfet L=0.35U W=2U
Mr7esd_Mclamp_f7 VDDIO VSS VSS VSS nfet L=0.35U W=2U
Mr7esd_Mclamp_f8 VDDIO VSS VSS VSS nfet L=0.35U W=2U
Mr7esd_Mclamp_f9 VDDIO VSS VSS VSS nfet L=0.35U W=2U
Mr7esd_Mclamp_f10 VDDIO VSS VSS VSS nfet L=0.35U W=2U
Mr7esd_Mclamp_f11 VDDIO VSS VSS VSS nfet L=0.35U W=2U
Mr7esd_Mclamp_f12 VDDIO VSS VSS VSS nfet L=0.35U W=2U
Mr7esd_Mclamp_f13 VDDIO VSS VSS VSS nfet L=0.35U W=2U
Mr7esd_Mclamp_f14 VDDIO VSS VSS VSS nfet L=0.35U W=2U
Mr7esd_Mclamp_f15 VDDIO VSS VSS VSS nfet L=0.35U W=2U
Mr7esd_Mclamp_f16 VDDIO VSS VSS VSS nfet L=0.35U W=2U
Mr7esd_Mclamp_f17 VDDIO VSS VSS VSS nfet L=0.35U W=2U
Mr7esd_Mclamp_f18 VDDIO VSS VSS VSS nfet L=0.35U W=2U
Mr7esd_Mclamp_f19 VDDIO VSS VSS VSS nfet L=0.35U W=2U
Xr7esd_Resd PAD$33 PADI_R7 VSS rppd r=164.6 L=1U W=2U
Dr7esd_Dp2 PADI_R7 VDDIO dpantenna A=4P P=8U
Mr7esd_Mn2_f0 PADI_R7 VSS VSS VSS nfet L=0.13U W=1U
Xr7rx_Rdiv1 VDDIO r7rx/vrn VSS rppd r=24804.0 L=48U W=0.5U
Xr7rx_Rdiv2 r7rx/vrn VSS VSS rppd r=24804.0 L=48U W=0.5U
Mr7rx_Mtail_f0 r7rx/s1 VDDIO VSS VSS nfet L=0.5U W=1U
Mr7rx_Mtail_f1 r7rx/s1 VDDIO VSS VSS nfet L=0.5U W=1U
Mr7rx_Mnp_f0 r7rx/d1 PADI_R7 r7rx/s1 VSS nfet L=0.5U W=0.5U
Mr7rx_Mnp_f1 r7rx/d1 PADI_R7 r7rx/s1 VSS nfet L=0.5U W=0.5U
Mr7rx_Mnn_f0 r7rx/d2 r7rx/vrn r7rx/s1 VSS nfet L=0.5U W=0.5U
Mr7rx_Mnn_f1 r7rx/d2 r7rx/vrn r7rx/s1 VSS nfet L=0.5U W=0.5U
Mr7rx_Mlp_f0 r7rx/d2 r7rx/d2 VDDIO VDDIO pfet L=0.25U W=1U
Mr7rx_Mlp_f1 r7rx/d2 r7rx/d2 VDDIO VDDIO pfet L=0.25U W=1U
Mr7rx_Mlp_f2 r7rx/d2 r7rx/d2 VDDIO VDDIO pfet L=0.25U W=1U
Mr7rx_Mlp_f3 r7rx/d2 r7rx/d2 VDDIO VDDIO pfet L=0.25U W=1U
Mr7rx_Mln_f0 r7rx/d1 r7rx/d2 VDDIO VDDIO pfet L=0.25U W=1U
Mr7rx_Mln_f1 r7rx/d1 r7rx/d2 VDDIO VDDIO pfet L=0.25U W=1U
Mr7rx_Mln_f2 r7rx/d1 r7rx/d2 VDDIO VDDIO pfet L=0.25U W=1U
Mr7rx_Mln_f3 r7rx/d1 r7rx/d2 VDDIO VDDIO pfet L=0.25U W=1U
Mr7rx_Mi2p_f0 DOUT$7 r7rx/d1 VDDIO VDDIO pfet L=0.13U W=2U
Mr7rx_Mi2n_f0 DOUT$7 r7rx/d1 VSS VSS nfet L=0.13U W=1U
Dr8esd_Dp1 PAD$34 VDDIO diodevdd_mod A=35P P=58.08U
Dr8esd_Dp1_dsub VSS VDDIO dsub_2kv_mod A=224.956P P=81.12U
Mr8esd_Mn1_f0 PAD$34 VSS VSS VSS nfet L=0.13U W=2U
Mr8esd_Mn1_f1 PAD$34 VSS VSS VSS nfet L=0.13U W=2U
Mr8esd_Mn1_f2 PAD$34 VSS VSS VSS nfet L=0.13U W=2U
Mr8esd_Mn1_f3 PAD$34 VSS VSS VSS nfet L=0.13U W=2U
Mr8esd_Mn1_f4 PAD$34 VSS VSS VSS nfet L=0.13U W=2U
Mr8esd_Mn1_f5 PAD$34 VSS VSS VSS nfet L=0.13U W=2U
Mr8esd_Mn1_f6 PAD$34 VSS VSS VSS nfet L=0.13U W=2U
Mr8esd_Mn1_f7 PAD$34 VSS VSS VSS nfet L=0.13U W=2U
Mr8esd_Mn1_f8 PAD$34 VSS VSS VSS nfet L=0.13U W=2U
Mr8esd_Mn1_f9 PAD$34 VSS VSS VSS nfet L=0.13U W=2U
Mr8esd_Mclamp_f0 VDDIO VSS VSS VSS nfet L=0.35U W=2U
Mr8esd_Mclamp_f1 VDDIO VSS VSS VSS nfet L=0.35U W=2U
Mr8esd_Mclamp_f2 VDDIO VSS VSS VSS nfet L=0.35U W=2U
Mr8esd_Mclamp_f3 VDDIO VSS VSS VSS nfet L=0.35U W=2U
Mr8esd_Mclamp_f4 VDDIO VSS VSS VSS nfet L=0.35U W=2U
Mr8esd_Mclamp_f5 VDDIO VSS VSS VSS nfet L=0.35U W=2U
Mr8esd_Mclamp_f6 VDDIO VSS VSS VSS nfet L=0.35U W=2U
Mr8esd_Mclamp_f7 VDDIO VSS VSS VSS nfet L=0.35U W=2U
Mr8esd_Mclamp_f8 VDDIO VSS VSS VSS nfet L=0.35U W=2U
Mr8esd_Mclamp_f9 VDDIO VSS VSS VSS nfet L=0.35U W=2U
Mr8esd_Mclamp_f10 VDDIO VSS VSS VSS nfet L=0.35U W=2U
Mr8esd_Mclamp_f11 VDDIO VSS VSS VSS nfet L=0.35U W=2U
Mr8esd_Mclamp_f12 VDDIO VSS VSS VSS nfet L=0.35U W=2U
Mr8esd_Mclamp_f13 VDDIO VSS VSS VSS nfet L=0.35U W=2U
Mr8esd_Mclamp_f14 VDDIO VSS VSS VSS nfet L=0.35U W=2U
Mr8esd_Mclamp_f15 VDDIO VSS VSS VSS nfet L=0.35U W=2U
Mr8esd_Mclamp_f16 VDDIO VSS VSS VSS nfet L=0.35U W=2U
Mr8esd_Mclamp_f17 VDDIO VSS VSS VSS nfet L=0.35U W=2U
Mr8esd_Mclamp_f18 VDDIO VSS VSS VSS nfet L=0.35U W=2U
Mr8esd_Mclamp_f19 VDDIO VSS VSS VSS nfet L=0.35U W=2U
Xr8esd_Resd PAD$34 PADI_R8 VSS rppd r=164.6 L=1U W=2U
Dr8esd_Dp2 PADI_R8 VDDIO dpantenna A=4P P=8U
Mr8esd_Mn2_f0 PADI_R8 VSS VSS VSS nfet L=0.13U W=1U
Xr8rx_Rdiv1 VDDIO r8rx/vrn VSS rppd r=24804.0 L=48U W=0.5U
Xr8rx_Rdiv2 r8rx/vrn VSS VSS rppd r=24804.0 L=48U W=0.5U
Mr8rx_Mtail_f0 r8rx/s1 VDDIO VSS VSS nfet L=0.5U W=1U
Mr8rx_Mtail_f1 r8rx/s1 VDDIO VSS VSS nfet L=0.5U W=1U
Mr8rx_Mnp_f0 r8rx/d1 PADI_R8 r8rx/s1 VSS nfet L=0.5U W=0.5U
Mr8rx_Mnp_f1 r8rx/d1 PADI_R8 r8rx/s1 VSS nfet L=0.5U W=0.5U
Mr8rx_Mnn_f0 r8rx/d2 r8rx/vrn r8rx/s1 VSS nfet L=0.5U W=0.5U
Mr8rx_Mnn_f1 r8rx/d2 r8rx/vrn r8rx/s1 VSS nfet L=0.5U W=0.5U
Mr8rx_Mlp_f0 r8rx/d2 r8rx/d2 VDDIO VDDIO pfet L=0.25U W=1U
Mr8rx_Mlp_f1 r8rx/d2 r8rx/d2 VDDIO VDDIO pfet L=0.25U W=1U
Mr8rx_Mlp_f2 r8rx/d2 r8rx/d2 VDDIO VDDIO pfet L=0.25U W=1U
Mr8rx_Mlp_f3 r8rx/d2 r8rx/d2 VDDIO VDDIO pfet L=0.25U W=1U
Mr8rx_Mln_f0 r8rx/d1 r8rx/d2 VDDIO VDDIO pfet L=0.25U W=1U
Mr8rx_Mln_f1 r8rx/d1 r8rx/d2 VDDIO VDDIO pfet L=0.25U W=1U
Mr8rx_Mln_f2 r8rx/d1 r8rx/d2 VDDIO VDDIO pfet L=0.25U W=1U
Mr8rx_Mln_f3 r8rx/d1 r8rx/d2 VDDIO VDDIO pfet L=0.25U W=1U
Mr8rx_Mi2p_f0 DOUT$8 r8rx/d1 VDDIO VDDIO pfet L=0.13U W=2U
Mr8rx_Mi2n_f0 DOUT$8 r8rx/d1 VSS VSS nfet L=0.13U W=1U
Dr9esd_Dp1 PAD$35 VDDIO diodevdd_mod A=35P P=58.08U
Dr9esd_Dp1_dsub VSS VDDIO dsub_2kv_mod A=224.956P P=81.12U
Mr9esd_Mn1_f0 PAD$35 VSS VSS VSS nfet L=0.13U W=2U
Mr9esd_Mn1_f1 PAD$35 VSS VSS VSS nfet L=0.13U W=2U
Mr9esd_Mn1_f2 PAD$35 VSS VSS VSS nfet L=0.13U W=2U
Mr9esd_Mn1_f3 PAD$35 VSS VSS VSS nfet L=0.13U W=2U
Mr9esd_Mn1_f4 PAD$35 VSS VSS VSS nfet L=0.13U W=2U
Mr9esd_Mn1_f5 PAD$35 VSS VSS VSS nfet L=0.13U W=2U
Mr9esd_Mn1_f6 PAD$35 VSS VSS VSS nfet L=0.13U W=2U
Mr9esd_Mn1_f7 PAD$35 VSS VSS VSS nfet L=0.13U W=2U
Mr9esd_Mn1_f8 PAD$35 VSS VSS VSS nfet L=0.13U W=2U
Mr9esd_Mn1_f9 PAD$35 VSS VSS VSS nfet L=0.13U W=2U
Mr9esd_Mclamp_f0 VDDIO VSS VSS VSS nfet L=0.35U W=2U
Mr9esd_Mclamp_f1 VDDIO VSS VSS VSS nfet L=0.35U W=2U
Mr9esd_Mclamp_f2 VDDIO VSS VSS VSS nfet L=0.35U W=2U
Mr9esd_Mclamp_f3 VDDIO VSS VSS VSS nfet L=0.35U W=2U
Mr9esd_Mclamp_f4 VDDIO VSS VSS VSS nfet L=0.35U W=2U
Mr9esd_Mclamp_f5 VDDIO VSS VSS VSS nfet L=0.35U W=2U
Mr9esd_Mclamp_f6 VDDIO VSS VSS VSS nfet L=0.35U W=2U
Mr9esd_Mclamp_f7 VDDIO VSS VSS VSS nfet L=0.35U W=2U
Mr9esd_Mclamp_f8 VDDIO VSS VSS VSS nfet L=0.35U W=2U
Mr9esd_Mclamp_f9 VDDIO VSS VSS VSS nfet L=0.35U W=2U
Mr9esd_Mclamp_f10 VDDIO VSS VSS VSS nfet L=0.35U W=2U
Mr9esd_Mclamp_f11 VDDIO VSS VSS VSS nfet L=0.35U W=2U
Mr9esd_Mclamp_f12 VDDIO VSS VSS VSS nfet L=0.35U W=2U
Mr9esd_Mclamp_f13 VDDIO VSS VSS VSS nfet L=0.35U W=2U
Mr9esd_Mclamp_f14 VDDIO VSS VSS VSS nfet L=0.35U W=2U
Mr9esd_Mclamp_f15 VDDIO VSS VSS VSS nfet L=0.35U W=2U
Mr9esd_Mclamp_f16 VDDIO VSS VSS VSS nfet L=0.35U W=2U
Mr9esd_Mclamp_f17 VDDIO VSS VSS VSS nfet L=0.35U W=2U
Mr9esd_Mclamp_f18 VDDIO VSS VSS VSS nfet L=0.35U W=2U
Mr9esd_Mclamp_f19 VDDIO VSS VSS VSS nfet L=0.35U W=2U
Xr9esd_Resd PAD$35 PADI_R9 VSS rppd r=164.6 L=1U W=2U
Dr9esd_Dp2 PADI_R9 VDDIO dpantenna A=4P P=8U
Mr9esd_Mn2_f0 PADI_R9 VSS VSS VSS nfet L=0.13U W=1U
Xr9rx_Rdiv1 VDDIO r9rx/vrn VSS rppd r=24804.0 L=48U W=0.5U
Xr9rx_Rdiv2 r9rx/vrn VSS VSS rppd r=24804.0 L=48U W=0.5U
Mr9rx_Mtail_f0 r9rx/s1 VDDIO VSS VSS nfet L=0.5U W=1U
Mr9rx_Mtail_f1 r9rx/s1 VDDIO VSS VSS nfet L=0.5U W=1U
Mr9rx_Mnp_f0 r9rx/d1 PADI_R9 r9rx/s1 VSS nfet L=0.5U W=0.5U
Mr9rx_Mnp_f1 r9rx/d1 PADI_R9 r9rx/s1 VSS nfet L=0.5U W=0.5U
Mr9rx_Mnn_f0 r9rx/d2 r9rx/vrn r9rx/s1 VSS nfet L=0.5U W=0.5U
Mr9rx_Mnn_f1 r9rx/d2 r9rx/vrn r9rx/s1 VSS nfet L=0.5U W=0.5U
Mr9rx_Mlp_f0 r9rx/d2 r9rx/d2 VDDIO VDDIO pfet L=0.25U W=1U
Mr9rx_Mlp_f1 r9rx/d2 r9rx/d2 VDDIO VDDIO pfet L=0.25U W=1U
Mr9rx_Mlp_f2 r9rx/d2 r9rx/d2 VDDIO VDDIO pfet L=0.25U W=1U
Mr9rx_Mlp_f3 r9rx/d2 r9rx/d2 VDDIO VDDIO pfet L=0.25U W=1U
Mr9rx_Mln_f0 r9rx/d1 r9rx/d2 VDDIO VDDIO pfet L=0.25U W=1U
Mr9rx_Mln_f1 r9rx/d1 r9rx/d2 VDDIO VDDIO pfet L=0.25U W=1U
Mr9rx_Mln_f2 r9rx/d1 r9rx/d2 VDDIO VDDIO pfet L=0.25U W=1U
Mr9rx_Mln_f3 r9rx/d1 r9rx/d2 VDDIO VDDIO pfet L=0.25U W=1U
Mr9rx_Mi2p_f0 DOUT$9 r9rx/d1 VDDIO VDDIO pfet L=0.13U W=2U
Mr9rx_Mi2n_f0 DOUT$9 r9rx/d1 VSS VSS nfet L=0.13U W=1U
Dr10esd_Dp1 PAD$36 VDDIO diodevdd_mod A=35P P=58.08U
Dr10esd_Dp1_dsub VSS VDDIO dsub_2kv_mod A=224.956P P=81.12U
Mr10esd_Mn1_f0 PAD$36 VSS VSS VSS nfet L=0.13U W=2U
Mr10esd_Mn1_f1 PAD$36 VSS VSS VSS nfet L=0.13U W=2U
Mr10esd_Mn1_f2 PAD$36 VSS VSS VSS nfet L=0.13U W=2U
Mr10esd_Mn1_f3 PAD$36 VSS VSS VSS nfet L=0.13U W=2U
Mr10esd_Mn1_f4 PAD$36 VSS VSS VSS nfet L=0.13U W=2U
Mr10esd_Mn1_f5 PAD$36 VSS VSS VSS nfet L=0.13U W=2U
Mr10esd_Mn1_f6 PAD$36 VSS VSS VSS nfet L=0.13U W=2U
Mr10esd_Mn1_f7 PAD$36 VSS VSS VSS nfet L=0.13U W=2U
Mr10esd_Mn1_f8 PAD$36 VSS VSS VSS nfet L=0.13U W=2U
Mr10esd_Mn1_f9 PAD$36 VSS VSS VSS nfet L=0.13U W=2U
Mr10esd_Mclamp_f0 VDDIO VSS VSS VSS nfet L=0.35U W=2U
Mr10esd_Mclamp_f1 VDDIO VSS VSS VSS nfet L=0.35U W=2U
Mr10esd_Mclamp_f2 VDDIO VSS VSS VSS nfet L=0.35U W=2U
Mr10esd_Mclamp_f3 VDDIO VSS VSS VSS nfet L=0.35U W=2U
Mr10esd_Mclamp_f4 VDDIO VSS VSS VSS nfet L=0.35U W=2U
Mr10esd_Mclamp_f5 VDDIO VSS VSS VSS nfet L=0.35U W=2U
Mr10esd_Mclamp_f6 VDDIO VSS VSS VSS nfet L=0.35U W=2U
Mr10esd_Mclamp_f7 VDDIO VSS VSS VSS nfet L=0.35U W=2U
Mr10esd_Mclamp_f8 VDDIO VSS VSS VSS nfet L=0.35U W=2U
Mr10esd_Mclamp_f9 VDDIO VSS VSS VSS nfet L=0.35U W=2U
Mr10esd_Mclamp_f10 VDDIO VSS VSS VSS nfet L=0.35U W=2U
Mr10esd_Mclamp_f11 VDDIO VSS VSS VSS nfet L=0.35U W=2U
Mr10esd_Mclamp_f12 VDDIO VSS VSS VSS nfet L=0.35U W=2U
Mr10esd_Mclamp_f13 VDDIO VSS VSS VSS nfet L=0.35U W=2U
Mr10esd_Mclamp_f14 VDDIO VSS VSS VSS nfet L=0.35U W=2U
Mr10esd_Mclamp_f15 VDDIO VSS VSS VSS nfet L=0.35U W=2U
Mr10esd_Mclamp_f16 VDDIO VSS VSS VSS nfet L=0.35U W=2U
Mr10esd_Mclamp_f17 VDDIO VSS VSS VSS nfet L=0.35U W=2U
Mr10esd_Mclamp_f18 VDDIO VSS VSS VSS nfet L=0.35U W=2U
Mr10esd_Mclamp_f19 VDDIO VSS VSS VSS nfet L=0.35U W=2U
Xr10esd_Resd PAD$36 PADI_R10 VSS rppd r=164.6 L=1U W=2U
Dr10esd_Dp2 PADI_R10 VDDIO dpantenna A=4P P=8U
Mr10esd_Mn2_f0 PADI_R10 VSS VSS VSS nfet L=0.13U W=1U
Xr10rx_Rdiv1 VDDIO r10rx/vrn VSS rppd r=24804.0 L=48U W=0.5U
Xr10rx_Rdiv2 r10rx/vrn VSS VSS rppd r=24804.0 L=48U W=0.5U
Mr10rx_Mtail_f0 r10rx/s1 VDDIO VSS VSS nfet L=0.5U W=1U
Mr10rx_Mtail_f1 r10rx/s1 VDDIO VSS VSS nfet L=0.5U W=1U
Mr10rx_Mnp_f0 r10rx/d1 PADI_R10 r10rx/s1 VSS nfet L=0.5U W=0.5U
Mr10rx_Mnp_f1 r10rx/d1 PADI_R10 r10rx/s1 VSS nfet L=0.5U W=0.5U
Mr10rx_Mnn_f0 r10rx/d2 r10rx/vrn r10rx/s1 VSS nfet L=0.5U W=0.5U
Mr10rx_Mnn_f1 r10rx/d2 r10rx/vrn r10rx/s1 VSS nfet L=0.5U W=0.5U
Mr10rx_Mlp_f0 r10rx/d2 r10rx/d2 VDDIO VDDIO pfet L=0.25U W=1U
Mr10rx_Mlp_f1 r10rx/d2 r10rx/d2 VDDIO VDDIO pfet L=0.25U W=1U
Mr10rx_Mlp_f2 r10rx/d2 r10rx/d2 VDDIO VDDIO pfet L=0.25U W=1U
Mr10rx_Mlp_f3 r10rx/d2 r10rx/d2 VDDIO VDDIO pfet L=0.25U W=1U
Mr10rx_Mln_f0 r10rx/d1 r10rx/d2 VDDIO VDDIO pfet L=0.25U W=1U
Mr10rx_Mln_f1 r10rx/d1 r10rx/d2 VDDIO VDDIO pfet L=0.25U W=1U
Mr10rx_Mln_f2 r10rx/d1 r10rx/d2 VDDIO VDDIO pfet L=0.25U W=1U
Mr10rx_Mln_f3 r10rx/d1 r10rx/d2 VDDIO VDDIO pfet L=0.25U W=1U
Mr10rx_Mi2p_f0 DOUT$10 r10rx/d1 VDDIO VDDIO pfet L=0.13U W=2U
Mr10rx_Mi2n_f0 DOUT$10 r10rx/d1 VSS VSS nfet L=0.13U W=1U
Dr11esd_Dp1 PAD$37 VDDIO diodevdd_mod A=35P P=58.08U
Dr11esd_Dp1_dsub VSS VDDIO dsub_2kv_mod A=224.956P P=81.12U
Mr11esd_Mn1_f0 PAD$37 VSS VSS VSS nfet L=0.13U W=2U
Mr11esd_Mn1_f1 PAD$37 VSS VSS VSS nfet L=0.13U W=2U
Mr11esd_Mn1_f2 PAD$37 VSS VSS VSS nfet L=0.13U W=2U
Mr11esd_Mn1_f3 PAD$37 VSS VSS VSS nfet L=0.13U W=2U
Mr11esd_Mn1_f4 PAD$37 VSS VSS VSS nfet L=0.13U W=2U
Mr11esd_Mn1_f5 PAD$37 VSS VSS VSS nfet L=0.13U W=2U
Mr11esd_Mn1_f6 PAD$37 VSS VSS VSS nfet L=0.13U W=2U
Mr11esd_Mn1_f7 PAD$37 VSS VSS VSS nfet L=0.13U W=2U
Mr11esd_Mn1_f8 PAD$37 VSS VSS VSS nfet L=0.13U W=2U
Mr11esd_Mn1_f9 PAD$37 VSS VSS VSS nfet L=0.13U W=2U
Mr11esd_Mclamp_f0 VDDIO VSS VSS VSS nfet L=0.35U W=2U
Mr11esd_Mclamp_f1 VDDIO VSS VSS VSS nfet L=0.35U W=2U
Mr11esd_Mclamp_f2 VDDIO VSS VSS VSS nfet L=0.35U W=2U
Mr11esd_Mclamp_f3 VDDIO VSS VSS VSS nfet L=0.35U W=2U
Mr11esd_Mclamp_f4 VDDIO VSS VSS VSS nfet L=0.35U W=2U
Mr11esd_Mclamp_f5 VDDIO VSS VSS VSS nfet L=0.35U W=2U
Mr11esd_Mclamp_f6 VDDIO VSS VSS VSS nfet L=0.35U W=2U
Mr11esd_Mclamp_f7 VDDIO VSS VSS VSS nfet L=0.35U W=2U
Mr11esd_Mclamp_f8 VDDIO VSS VSS VSS nfet L=0.35U W=2U
Mr11esd_Mclamp_f9 VDDIO VSS VSS VSS nfet L=0.35U W=2U
Mr11esd_Mclamp_f10 VDDIO VSS VSS VSS nfet L=0.35U W=2U
Mr11esd_Mclamp_f11 VDDIO VSS VSS VSS nfet L=0.35U W=2U
Mr11esd_Mclamp_f12 VDDIO VSS VSS VSS nfet L=0.35U W=2U
Mr11esd_Mclamp_f13 VDDIO VSS VSS VSS nfet L=0.35U W=2U
Mr11esd_Mclamp_f14 VDDIO VSS VSS VSS nfet L=0.35U W=2U
Mr11esd_Mclamp_f15 VDDIO VSS VSS VSS nfet L=0.35U W=2U
Mr11esd_Mclamp_f16 VDDIO VSS VSS VSS nfet L=0.35U W=2U
Mr11esd_Mclamp_f17 VDDIO VSS VSS VSS nfet L=0.35U W=2U
Mr11esd_Mclamp_f18 VDDIO VSS VSS VSS nfet L=0.35U W=2U
Mr11esd_Mclamp_f19 VDDIO VSS VSS VSS nfet L=0.35U W=2U
Xr11esd_Resd PAD$37 PADI_R11 VSS rppd r=164.6 L=1U W=2U
Dr11esd_Dp2 PADI_R11 VDDIO dpantenna A=4P P=8U
Mr11esd_Mn2_f0 PADI_R11 VSS VSS VSS nfet L=0.13U W=1U
Xr11rx_Rdiv1 VDDIO r11rx/vrn VSS rppd r=24804.0 L=48U W=0.5U
Xr11rx_Rdiv2 r11rx/vrn VSS VSS rppd r=24804.0 L=48U W=0.5U
Mr11rx_Mtail_f0 r11rx/s1 VDDIO VSS VSS nfet L=0.5U W=1U
Mr11rx_Mtail_f1 r11rx/s1 VDDIO VSS VSS nfet L=0.5U W=1U
Mr11rx_Mnp_f0 r11rx/d1 PADI_R11 r11rx/s1 VSS nfet L=0.5U W=0.5U
Mr11rx_Mnp_f1 r11rx/d1 PADI_R11 r11rx/s1 VSS nfet L=0.5U W=0.5U
Mr11rx_Mnn_f0 r11rx/d2 r11rx/vrn r11rx/s1 VSS nfet L=0.5U W=0.5U
Mr11rx_Mnn_f1 r11rx/d2 r11rx/vrn r11rx/s1 VSS nfet L=0.5U W=0.5U
Mr11rx_Mlp_f0 r11rx/d2 r11rx/d2 VDDIO VDDIO pfet L=0.25U W=1U
Mr11rx_Mlp_f1 r11rx/d2 r11rx/d2 VDDIO VDDIO pfet L=0.25U W=1U
Mr11rx_Mlp_f2 r11rx/d2 r11rx/d2 VDDIO VDDIO pfet L=0.25U W=1U
Mr11rx_Mlp_f3 r11rx/d2 r11rx/d2 VDDIO VDDIO pfet L=0.25U W=1U
Mr11rx_Mln_f0 r11rx/d1 r11rx/d2 VDDIO VDDIO pfet L=0.25U W=1U
Mr11rx_Mln_f1 r11rx/d1 r11rx/d2 VDDIO VDDIO pfet L=0.25U W=1U
Mr11rx_Mln_f2 r11rx/d1 r11rx/d2 VDDIO VDDIO pfet L=0.25U W=1U
Mr11rx_Mln_f3 r11rx/d1 r11rx/d2 VDDIO VDDIO pfet L=0.25U W=1U
Mr11rx_Mi2p_f0 DOUT$11 r11rx/d1 VDDIO VDDIO pfet L=0.13U W=2U
Mr11rx_Mi2n_f0 DOUT$11 r11rx/d1 VSS VSS nfet L=0.13U W=1U
Dr12esd_Dp1 PAD$38 VDDIO diodevdd_mod A=35P P=58.08U
Dr12esd_Dp1_dsub VSS VDDIO dsub_2kv_mod A=224.956P P=81.12U
Mr12esd_Mn1_f0 PAD$38 VSS VSS VSS nfet L=0.13U W=2U
Mr12esd_Mn1_f1 PAD$38 VSS VSS VSS nfet L=0.13U W=2U
Mr12esd_Mn1_f2 PAD$38 VSS VSS VSS nfet L=0.13U W=2U
Mr12esd_Mn1_f3 PAD$38 VSS VSS VSS nfet L=0.13U W=2U
Mr12esd_Mn1_f4 PAD$38 VSS VSS VSS nfet L=0.13U W=2U
Mr12esd_Mn1_f5 PAD$38 VSS VSS VSS nfet L=0.13U W=2U
Mr12esd_Mn1_f6 PAD$38 VSS VSS VSS nfet L=0.13U W=2U
Mr12esd_Mn1_f7 PAD$38 VSS VSS VSS nfet L=0.13U W=2U
Mr12esd_Mn1_f8 PAD$38 VSS VSS VSS nfet L=0.13U W=2U
Mr12esd_Mn1_f9 PAD$38 VSS VSS VSS nfet L=0.13U W=2U
Mr12esd_Mclamp_f0 VDDIO VSS VSS VSS nfet L=0.35U W=2U
Mr12esd_Mclamp_f1 VDDIO VSS VSS VSS nfet L=0.35U W=2U
Mr12esd_Mclamp_f2 VDDIO VSS VSS VSS nfet L=0.35U W=2U
Mr12esd_Mclamp_f3 VDDIO VSS VSS VSS nfet L=0.35U W=2U
Mr12esd_Mclamp_f4 VDDIO VSS VSS VSS nfet L=0.35U W=2U
Mr12esd_Mclamp_f5 VDDIO VSS VSS VSS nfet L=0.35U W=2U
Mr12esd_Mclamp_f6 VDDIO VSS VSS VSS nfet L=0.35U W=2U
Mr12esd_Mclamp_f7 VDDIO VSS VSS VSS nfet L=0.35U W=2U
Mr12esd_Mclamp_f8 VDDIO VSS VSS VSS nfet L=0.35U W=2U
Mr12esd_Mclamp_f9 VDDIO VSS VSS VSS nfet L=0.35U W=2U
Mr12esd_Mclamp_f10 VDDIO VSS VSS VSS nfet L=0.35U W=2U
Mr12esd_Mclamp_f11 VDDIO VSS VSS VSS nfet L=0.35U W=2U
Mr12esd_Mclamp_f12 VDDIO VSS VSS VSS nfet L=0.35U W=2U
Mr12esd_Mclamp_f13 VDDIO VSS VSS VSS nfet L=0.35U W=2U
Mr12esd_Mclamp_f14 VDDIO VSS VSS VSS nfet L=0.35U W=2U
Mr12esd_Mclamp_f15 VDDIO VSS VSS VSS nfet L=0.35U W=2U
Mr12esd_Mclamp_f16 VDDIO VSS VSS VSS nfet L=0.35U W=2U
Mr12esd_Mclamp_f17 VDDIO VSS VSS VSS nfet L=0.35U W=2U
Mr12esd_Mclamp_f18 VDDIO VSS VSS VSS nfet L=0.35U W=2U
Mr12esd_Mclamp_f19 VDDIO VSS VSS VSS nfet L=0.35U W=2U
Xr12esd_Resd PAD$38 PADI_R12 VSS rppd r=164.6 L=1U W=2U
Dr12esd_Dp2 PADI_R12 VDDIO dpantenna A=4P P=8U
Mr12esd_Mn2_f0 PADI_R12 VSS VSS VSS nfet L=0.13U W=1U
Xr12rx_Rdiv1 VDDIO r12rx/vrn VSS rppd r=24804.0 L=48U W=0.5U
Xr12rx_Rdiv2 r12rx/vrn VSS VSS rppd r=24804.0 L=48U W=0.5U
Mr12rx_Mtail_f0 r12rx/s1 VDDIO VSS VSS nfet L=0.5U W=1U
Mr12rx_Mtail_f1 r12rx/s1 VDDIO VSS VSS nfet L=0.5U W=1U
Mr12rx_Mnp_f0 r12rx/d1 PADI_R12 r12rx/s1 VSS nfet L=0.5U W=0.5U
Mr12rx_Mnp_f1 r12rx/d1 PADI_R12 r12rx/s1 VSS nfet L=0.5U W=0.5U
Mr12rx_Mnn_f0 r12rx/d2 r12rx/vrn r12rx/s1 VSS nfet L=0.5U W=0.5U
Mr12rx_Mnn_f1 r12rx/d2 r12rx/vrn r12rx/s1 VSS nfet L=0.5U W=0.5U
Mr12rx_Mlp_f0 r12rx/d2 r12rx/d2 VDDIO VDDIO pfet L=0.25U W=1U
Mr12rx_Mlp_f1 r12rx/d2 r12rx/d2 VDDIO VDDIO pfet L=0.25U W=1U
Mr12rx_Mlp_f2 r12rx/d2 r12rx/d2 VDDIO VDDIO pfet L=0.25U W=1U
Mr12rx_Mlp_f3 r12rx/d2 r12rx/d2 VDDIO VDDIO pfet L=0.25U W=1U
Mr12rx_Mln_f0 r12rx/d1 r12rx/d2 VDDIO VDDIO pfet L=0.25U W=1U
Mr12rx_Mln_f1 r12rx/d1 r12rx/d2 VDDIO VDDIO pfet L=0.25U W=1U
Mr12rx_Mln_f2 r12rx/d1 r12rx/d2 VDDIO VDDIO pfet L=0.25U W=1U
Mr12rx_Mln_f3 r12rx/d1 r12rx/d2 VDDIO VDDIO pfet L=0.25U W=1U
Mr12rx_Mi2p_f0 DOUT$12 r12rx/d1 VDDIO VDDIO pfet L=0.13U W=2U
Mr12rx_Mi2n_f0 DOUT$12 r12rx/d1 VSS VSS nfet L=0.13U W=1U
Dr13esd_Dp1 PAD$39 VDDIO diodevdd_mod A=35P P=58.08U
Dr13esd_Dp1_dsub VSS VDDIO dsub_2kv_mod A=224.956P P=81.12U
Mr13esd_Mn1_f0 PAD$39 VSS VSS VSS nfet L=0.13U W=2U
Mr13esd_Mn1_f1 PAD$39 VSS VSS VSS nfet L=0.13U W=2U
Mr13esd_Mn1_f2 PAD$39 VSS VSS VSS nfet L=0.13U W=2U
Mr13esd_Mn1_f3 PAD$39 VSS VSS VSS nfet L=0.13U W=2U
Mr13esd_Mn1_f4 PAD$39 VSS VSS VSS nfet L=0.13U W=2U
Mr13esd_Mn1_f5 PAD$39 VSS VSS VSS nfet L=0.13U W=2U
Mr13esd_Mn1_f6 PAD$39 VSS VSS VSS nfet L=0.13U W=2U
Mr13esd_Mn1_f7 PAD$39 VSS VSS VSS nfet L=0.13U W=2U
Mr13esd_Mn1_f8 PAD$39 VSS VSS VSS nfet L=0.13U W=2U
Mr13esd_Mn1_f9 PAD$39 VSS VSS VSS nfet L=0.13U W=2U
Mr13esd_Mclamp_f0 VDDIO VSS VSS VSS nfet L=0.35U W=2U
Mr13esd_Mclamp_f1 VDDIO VSS VSS VSS nfet L=0.35U W=2U
Mr13esd_Mclamp_f2 VDDIO VSS VSS VSS nfet L=0.35U W=2U
Mr13esd_Mclamp_f3 VDDIO VSS VSS VSS nfet L=0.35U W=2U
Mr13esd_Mclamp_f4 VDDIO VSS VSS VSS nfet L=0.35U W=2U
Mr13esd_Mclamp_f5 VDDIO VSS VSS VSS nfet L=0.35U W=2U
Mr13esd_Mclamp_f6 VDDIO VSS VSS VSS nfet L=0.35U W=2U
Mr13esd_Mclamp_f7 VDDIO VSS VSS VSS nfet L=0.35U W=2U
Mr13esd_Mclamp_f8 VDDIO VSS VSS VSS nfet L=0.35U W=2U
Mr13esd_Mclamp_f9 VDDIO VSS VSS VSS nfet L=0.35U W=2U
Mr13esd_Mclamp_f10 VDDIO VSS VSS VSS nfet L=0.35U W=2U
Mr13esd_Mclamp_f11 VDDIO VSS VSS VSS nfet L=0.35U W=2U
Mr13esd_Mclamp_f12 VDDIO VSS VSS VSS nfet L=0.35U W=2U
Mr13esd_Mclamp_f13 VDDIO VSS VSS VSS nfet L=0.35U W=2U
Mr13esd_Mclamp_f14 VDDIO VSS VSS VSS nfet L=0.35U W=2U
Mr13esd_Mclamp_f15 VDDIO VSS VSS VSS nfet L=0.35U W=2U
Mr13esd_Mclamp_f16 VDDIO VSS VSS VSS nfet L=0.35U W=2U
Mr13esd_Mclamp_f17 VDDIO VSS VSS VSS nfet L=0.35U W=2U
Mr13esd_Mclamp_f18 VDDIO VSS VSS VSS nfet L=0.35U W=2U
Mr13esd_Mclamp_f19 VDDIO VSS VSS VSS nfet L=0.35U W=2U
Xr13esd_Resd PAD$39 PADI_R13 VSS rppd r=164.6 L=1U W=2U
Dr13esd_Dp2 PADI_R13 VDDIO dpantenna A=4P P=8U
Mr13esd_Mn2_f0 PADI_R13 VSS VSS VSS nfet L=0.13U W=1U
Xr13rx_Rdiv1 VDDIO r13rx/vrn VSS rppd r=24804.0 L=48U W=0.5U
Xr13rx_Rdiv2 r13rx/vrn VSS VSS rppd r=24804.0 L=48U W=0.5U
Mr13rx_Mtail_f0 r13rx/s1 VDDIO VSS VSS nfet L=0.5U W=1U
Mr13rx_Mtail_f1 r13rx/s1 VDDIO VSS VSS nfet L=0.5U W=1U
Mr13rx_Mnp_f0 r13rx/d1 PADI_R13 r13rx/s1 VSS nfet L=0.5U W=0.5U
Mr13rx_Mnp_f1 r13rx/d1 PADI_R13 r13rx/s1 VSS nfet L=0.5U W=0.5U
Mr13rx_Mnn_f0 r13rx/d2 r13rx/vrn r13rx/s1 VSS nfet L=0.5U W=0.5U
Mr13rx_Mnn_f1 r13rx/d2 r13rx/vrn r13rx/s1 VSS nfet L=0.5U W=0.5U
Mr13rx_Mlp_f0 r13rx/d2 r13rx/d2 VDDIO VDDIO pfet L=0.25U W=1U
Mr13rx_Mlp_f1 r13rx/d2 r13rx/d2 VDDIO VDDIO pfet L=0.25U W=1U
Mr13rx_Mlp_f2 r13rx/d2 r13rx/d2 VDDIO VDDIO pfet L=0.25U W=1U
Mr13rx_Mlp_f3 r13rx/d2 r13rx/d2 VDDIO VDDIO pfet L=0.25U W=1U
Mr13rx_Mln_f0 r13rx/d1 r13rx/d2 VDDIO VDDIO pfet L=0.25U W=1U
Mr13rx_Mln_f1 r13rx/d1 r13rx/d2 VDDIO VDDIO pfet L=0.25U W=1U
Mr13rx_Mln_f2 r13rx/d1 r13rx/d2 VDDIO VDDIO pfet L=0.25U W=1U
Mr13rx_Mln_f3 r13rx/d1 r13rx/d2 VDDIO VDDIO pfet L=0.25U W=1U
Mr13rx_Mi2p_f0 DOUT$13 r13rx/d1 VDDIO VDDIO pfet L=0.13U W=2U
Mr13rx_Mi2n_f0 DOUT$13 r13rx/d1 VSS VSS nfet L=0.13U W=1U
Dr14esd_Dp1 PAD$40 VDDIO diodevdd_mod A=35P P=58.08U
Dr14esd_Dp1_dsub VSS VDDIO dsub_2kv_mod A=224.956P P=81.12U
Mr14esd_Mn1_f0 PAD$40 VSS VSS VSS nfet L=0.13U W=2U
Mr14esd_Mn1_f1 PAD$40 VSS VSS VSS nfet L=0.13U W=2U
Mr14esd_Mn1_f2 PAD$40 VSS VSS VSS nfet L=0.13U W=2U
Mr14esd_Mn1_f3 PAD$40 VSS VSS VSS nfet L=0.13U W=2U
Mr14esd_Mn1_f4 PAD$40 VSS VSS VSS nfet L=0.13U W=2U
Mr14esd_Mn1_f5 PAD$40 VSS VSS VSS nfet L=0.13U W=2U
Mr14esd_Mn1_f6 PAD$40 VSS VSS VSS nfet L=0.13U W=2U
Mr14esd_Mn1_f7 PAD$40 VSS VSS VSS nfet L=0.13U W=2U
Mr14esd_Mn1_f8 PAD$40 VSS VSS VSS nfet L=0.13U W=2U
Mr14esd_Mn1_f9 PAD$40 VSS VSS VSS nfet L=0.13U W=2U
Mr14esd_Mclamp_f0 VDDIO VSS VSS VSS nfet L=0.35U W=2U
Mr14esd_Mclamp_f1 VDDIO VSS VSS VSS nfet L=0.35U W=2U
Mr14esd_Mclamp_f2 VDDIO VSS VSS VSS nfet L=0.35U W=2U
Mr14esd_Mclamp_f3 VDDIO VSS VSS VSS nfet L=0.35U W=2U
Mr14esd_Mclamp_f4 VDDIO VSS VSS VSS nfet L=0.35U W=2U
Mr14esd_Mclamp_f5 VDDIO VSS VSS VSS nfet L=0.35U W=2U
Mr14esd_Mclamp_f6 VDDIO VSS VSS VSS nfet L=0.35U W=2U
Mr14esd_Mclamp_f7 VDDIO VSS VSS VSS nfet L=0.35U W=2U
Mr14esd_Mclamp_f8 VDDIO VSS VSS VSS nfet L=0.35U W=2U
Mr14esd_Mclamp_f9 VDDIO VSS VSS VSS nfet L=0.35U W=2U
Mr14esd_Mclamp_f10 VDDIO VSS VSS VSS nfet L=0.35U W=2U
Mr14esd_Mclamp_f11 VDDIO VSS VSS VSS nfet L=0.35U W=2U
Mr14esd_Mclamp_f12 VDDIO VSS VSS VSS nfet L=0.35U W=2U
Mr14esd_Mclamp_f13 VDDIO VSS VSS VSS nfet L=0.35U W=2U
Mr14esd_Mclamp_f14 VDDIO VSS VSS VSS nfet L=0.35U W=2U
Mr14esd_Mclamp_f15 VDDIO VSS VSS VSS nfet L=0.35U W=2U
Mr14esd_Mclamp_f16 VDDIO VSS VSS VSS nfet L=0.35U W=2U
Mr14esd_Mclamp_f17 VDDIO VSS VSS VSS nfet L=0.35U W=2U
Mr14esd_Mclamp_f18 VDDIO VSS VSS VSS nfet L=0.35U W=2U
Mr14esd_Mclamp_f19 VDDIO VSS VSS VSS nfet L=0.35U W=2U
Xr14esd_Resd PAD$40 PADI_R14 VSS rppd r=164.6 L=1U W=2U
Dr14esd_Dp2 PADI_R14 VDDIO dpantenna A=4P P=8U
Mr14esd_Mn2_f0 PADI_R14 VSS VSS VSS nfet L=0.13U W=1U
Xr14rx_Rdiv1 VDDIO r14rx/vrn VSS rppd r=24804.0 L=48U W=0.5U
Xr14rx_Rdiv2 r14rx/vrn VSS VSS rppd r=24804.0 L=48U W=0.5U
Mr14rx_Mtail_f0 r14rx/s1 VDDIO VSS VSS nfet L=0.5U W=1U
Mr14rx_Mtail_f1 r14rx/s1 VDDIO VSS VSS nfet L=0.5U W=1U
Mr14rx_Mnp_f0 r14rx/d1 PADI_R14 r14rx/s1 VSS nfet L=0.5U W=0.5U
Mr14rx_Mnp_f1 r14rx/d1 PADI_R14 r14rx/s1 VSS nfet L=0.5U W=0.5U
Mr14rx_Mnn_f0 r14rx/d2 r14rx/vrn r14rx/s1 VSS nfet L=0.5U W=0.5U
Mr14rx_Mnn_f1 r14rx/d2 r14rx/vrn r14rx/s1 VSS nfet L=0.5U W=0.5U
Mr14rx_Mlp_f0 r14rx/d2 r14rx/d2 VDDIO VDDIO pfet L=0.25U W=1U
Mr14rx_Mlp_f1 r14rx/d2 r14rx/d2 VDDIO VDDIO pfet L=0.25U W=1U
Mr14rx_Mlp_f2 r14rx/d2 r14rx/d2 VDDIO VDDIO pfet L=0.25U W=1U
Mr14rx_Mlp_f3 r14rx/d2 r14rx/d2 VDDIO VDDIO pfet L=0.25U W=1U
Mr14rx_Mln_f0 r14rx/d1 r14rx/d2 VDDIO VDDIO pfet L=0.25U W=1U
Mr14rx_Mln_f1 r14rx/d1 r14rx/d2 VDDIO VDDIO pfet L=0.25U W=1U
Mr14rx_Mln_f2 r14rx/d1 r14rx/d2 VDDIO VDDIO pfet L=0.25U W=1U
Mr14rx_Mln_f3 r14rx/d1 r14rx/d2 VDDIO VDDIO pfet L=0.25U W=1U
Mr14rx_Mi2p_f0 DOUT$14 r14rx/d1 VDDIO VDDIO pfet L=0.13U W=2U
Mr14rx_Mi2n_f0 DOUT$14 r14rx/d1 VSS VSS nfet L=0.13U W=1U
Dr15esd_Dp1 PAD$41 VDDIO diodevdd_mod A=35P P=58.08U
Dr15esd_Dp1_dsub VSS VDDIO dsub_2kv_mod A=224.956P P=81.12U
Mr15esd_Mn1_f0 PAD$41 VSS VSS VSS nfet L=0.13U W=2U
Mr15esd_Mn1_f1 PAD$41 VSS VSS VSS nfet L=0.13U W=2U
Mr15esd_Mn1_f2 PAD$41 VSS VSS VSS nfet L=0.13U W=2U
Mr15esd_Mn1_f3 PAD$41 VSS VSS VSS nfet L=0.13U W=2U
Mr15esd_Mn1_f4 PAD$41 VSS VSS VSS nfet L=0.13U W=2U
Mr15esd_Mn1_f5 PAD$41 VSS VSS VSS nfet L=0.13U W=2U
Mr15esd_Mn1_f6 PAD$41 VSS VSS VSS nfet L=0.13U W=2U
Mr15esd_Mn1_f7 PAD$41 VSS VSS VSS nfet L=0.13U W=2U
Mr15esd_Mn1_f8 PAD$41 VSS VSS VSS nfet L=0.13U W=2U
Mr15esd_Mn1_f9 PAD$41 VSS VSS VSS nfet L=0.13U W=2U
Mr15esd_Mclamp_f0 VDDIO VSS VSS VSS nfet L=0.35U W=2U
Mr15esd_Mclamp_f1 VDDIO VSS VSS VSS nfet L=0.35U W=2U
Mr15esd_Mclamp_f2 VDDIO VSS VSS VSS nfet L=0.35U W=2U
Mr15esd_Mclamp_f3 VDDIO VSS VSS VSS nfet L=0.35U W=2U
Mr15esd_Mclamp_f4 VDDIO VSS VSS VSS nfet L=0.35U W=2U
Mr15esd_Mclamp_f5 VDDIO VSS VSS VSS nfet L=0.35U W=2U
Mr15esd_Mclamp_f6 VDDIO VSS VSS VSS nfet L=0.35U W=2U
Mr15esd_Mclamp_f7 VDDIO VSS VSS VSS nfet L=0.35U W=2U
Mr15esd_Mclamp_f8 VDDIO VSS VSS VSS nfet L=0.35U W=2U
Mr15esd_Mclamp_f9 VDDIO VSS VSS VSS nfet L=0.35U W=2U
Mr15esd_Mclamp_f10 VDDIO VSS VSS VSS nfet L=0.35U W=2U
Mr15esd_Mclamp_f11 VDDIO VSS VSS VSS nfet L=0.35U W=2U
Mr15esd_Mclamp_f12 VDDIO VSS VSS VSS nfet L=0.35U W=2U
Mr15esd_Mclamp_f13 VDDIO VSS VSS VSS nfet L=0.35U W=2U
Mr15esd_Mclamp_f14 VDDIO VSS VSS VSS nfet L=0.35U W=2U
Mr15esd_Mclamp_f15 VDDIO VSS VSS VSS nfet L=0.35U W=2U
Mr15esd_Mclamp_f16 VDDIO VSS VSS VSS nfet L=0.35U W=2U
Mr15esd_Mclamp_f17 VDDIO VSS VSS VSS nfet L=0.35U W=2U
Mr15esd_Mclamp_f18 VDDIO VSS VSS VSS nfet L=0.35U W=2U
Mr15esd_Mclamp_f19 VDDIO VSS VSS VSS nfet L=0.35U W=2U
Xr15esd_Resd PAD$41 PADI_R15 VSS rppd r=164.6 L=1U W=2U
Dr15esd_Dp2 PADI_R15 VDDIO dpantenna A=4P P=8U
Mr15esd_Mn2_f0 PADI_R15 VSS VSS VSS nfet L=0.13U W=1U
Xr15rx_Rdiv1 VDDIO r15rx/vrn VSS rppd r=24804.0 L=48U W=0.5U
Xr15rx_Rdiv2 r15rx/vrn VSS VSS rppd r=24804.0 L=48U W=0.5U
Mr15rx_Mtail_f0 r15rx/s1 VDDIO VSS VSS nfet L=0.5U W=1U
Mr15rx_Mtail_f1 r15rx/s1 VDDIO VSS VSS nfet L=0.5U W=1U
Mr15rx_Mnp_f0 r15rx/d1 PADI_R15 r15rx/s1 VSS nfet L=0.5U W=0.5U
Mr15rx_Mnp_f1 r15rx/d1 PADI_R15 r15rx/s1 VSS nfet L=0.5U W=0.5U
Mr15rx_Mnn_f0 r15rx/d2 r15rx/vrn r15rx/s1 VSS nfet L=0.5U W=0.5U
Mr15rx_Mnn_f1 r15rx/d2 r15rx/vrn r15rx/s1 VSS nfet L=0.5U W=0.5U
Mr15rx_Mlp_f0 r15rx/d2 r15rx/d2 VDDIO VDDIO pfet L=0.25U W=1U
Mr15rx_Mlp_f1 r15rx/d2 r15rx/d2 VDDIO VDDIO pfet L=0.25U W=1U
Mr15rx_Mlp_f2 r15rx/d2 r15rx/d2 VDDIO VDDIO pfet L=0.25U W=1U
Mr15rx_Mlp_f3 r15rx/d2 r15rx/d2 VDDIO VDDIO pfet L=0.25U W=1U
Mr15rx_Mln_f0 r15rx/d1 r15rx/d2 VDDIO VDDIO pfet L=0.25U W=1U
Mr15rx_Mln_f1 r15rx/d1 r15rx/d2 VDDIO VDDIO pfet L=0.25U W=1U
Mr15rx_Mln_f2 r15rx/d1 r15rx/d2 VDDIO VDDIO pfet L=0.25U W=1U
Mr15rx_Mln_f3 r15rx/d1 r15rx/d2 VDDIO VDDIO pfet L=0.25U W=1U
Mr15rx_Mi2p_f0 DOUT$15 r15rx/d1 VDDIO VDDIO pfet L=0.13U W=2U
Mr15rx_Mi2n_f0 DOUT$15 r15rx/d1 VSS VSS nfet L=0.13U W=1U
Dr16esd_Dp1 PAD$42 VDDIO diodevdd_mod A=35P P=58.08U
Dr16esd_Dp1_dsub VSS VDDIO dsub_2kv_mod A=224.956P P=81.12U
Mr16esd_Mn1_f0 PAD$42 VSS VSS VSS nfet L=0.13U W=2U
Mr16esd_Mn1_f1 PAD$42 VSS VSS VSS nfet L=0.13U W=2U
Mr16esd_Mn1_f2 PAD$42 VSS VSS VSS nfet L=0.13U W=2U
Mr16esd_Mn1_f3 PAD$42 VSS VSS VSS nfet L=0.13U W=2U
Mr16esd_Mn1_f4 PAD$42 VSS VSS VSS nfet L=0.13U W=2U
Mr16esd_Mn1_f5 PAD$42 VSS VSS VSS nfet L=0.13U W=2U
Mr16esd_Mn1_f6 PAD$42 VSS VSS VSS nfet L=0.13U W=2U
Mr16esd_Mn1_f7 PAD$42 VSS VSS VSS nfet L=0.13U W=2U
Mr16esd_Mn1_f8 PAD$42 VSS VSS VSS nfet L=0.13U W=2U
Mr16esd_Mn1_f9 PAD$42 VSS VSS VSS nfet L=0.13U W=2U
Mr16esd_Mclamp_f0 VDDIO VSS VSS VSS nfet L=0.35U W=2U
Mr16esd_Mclamp_f1 VDDIO VSS VSS VSS nfet L=0.35U W=2U
Mr16esd_Mclamp_f2 VDDIO VSS VSS VSS nfet L=0.35U W=2U
Mr16esd_Mclamp_f3 VDDIO VSS VSS VSS nfet L=0.35U W=2U
Mr16esd_Mclamp_f4 VDDIO VSS VSS VSS nfet L=0.35U W=2U
Mr16esd_Mclamp_f5 VDDIO VSS VSS VSS nfet L=0.35U W=2U
Mr16esd_Mclamp_f6 VDDIO VSS VSS VSS nfet L=0.35U W=2U
Mr16esd_Mclamp_f7 VDDIO VSS VSS VSS nfet L=0.35U W=2U
Mr16esd_Mclamp_f8 VDDIO VSS VSS VSS nfet L=0.35U W=2U
Mr16esd_Mclamp_f9 VDDIO VSS VSS VSS nfet L=0.35U W=2U
Mr16esd_Mclamp_f10 VDDIO VSS VSS VSS nfet L=0.35U W=2U
Mr16esd_Mclamp_f11 VDDIO VSS VSS VSS nfet L=0.35U W=2U
Mr16esd_Mclamp_f12 VDDIO VSS VSS VSS nfet L=0.35U W=2U
Mr16esd_Mclamp_f13 VDDIO VSS VSS VSS nfet L=0.35U W=2U
Mr16esd_Mclamp_f14 VDDIO VSS VSS VSS nfet L=0.35U W=2U
Mr16esd_Mclamp_f15 VDDIO VSS VSS VSS nfet L=0.35U W=2U
Mr16esd_Mclamp_f16 VDDIO VSS VSS VSS nfet L=0.35U W=2U
Mr16esd_Mclamp_f17 VDDIO VSS VSS VSS nfet L=0.35U W=2U
Mr16esd_Mclamp_f18 VDDIO VSS VSS VSS nfet L=0.35U W=2U
Mr16esd_Mclamp_f19 VDDIO VSS VSS VSS nfet L=0.35U W=2U
Xr16esd_Resd PAD$42 PADI_R16 VSS rppd r=164.6 L=1U W=2U
Dr16esd_Dp2 PADI_R16 VDDIO dpantenna A=4P P=8U
Mr16esd_Mn2_f0 PADI_R16 VSS VSS VSS nfet L=0.13U W=1U
Xr16rx_Rdiv1 VDDIO r16rx/vrn VSS rppd r=24804.0 L=48U W=0.5U
Xr16rx_Rdiv2 r16rx/vrn VSS VSS rppd r=24804.0 L=48U W=0.5U
Mr16rx_Mtail_f0 r16rx/s1 VDDIO VSS VSS nfet L=0.5U W=1U
Mr16rx_Mtail_f1 r16rx/s1 VDDIO VSS VSS nfet L=0.5U W=1U
Mr16rx_Mnp_f0 r16rx/d1 PADI_R16 r16rx/s1 VSS nfet L=0.5U W=0.5U
Mr16rx_Mnp_f1 r16rx/d1 PADI_R16 r16rx/s1 VSS nfet L=0.5U W=0.5U
Mr16rx_Mnn_f0 r16rx/d2 r16rx/vrn r16rx/s1 VSS nfet L=0.5U W=0.5U
Mr16rx_Mnn_f1 r16rx/d2 r16rx/vrn r16rx/s1 VSS nfet L=0.5U W=0.5U
Mr16rx_Mlp_f0 r16rx/d2 r16rx/d2 VDDIO VDDIO pfet L=0.25U W=1U
Mr16rx_Mlp_f1 r16rx/d2 r16rx/d2 VDDIO VDDIO pfet L=0.25U W=1U
Mr16rx_Mlp_f2 r16rx/d2 r16rx/d2 VDDIO VDDIO pfet L=0.25U W=1U
Mr16rx_Mlp_f3 r16rx/d2 r16rx/d2 VDDIO VDDIO pfet L=0.25U W=1U
Mr16rx_Mln_f0 r16rx/d1 r16rx/d2 VDDIO VDDIO pfet L=0.25U W=1U
Mr16rx_Mln_f1 r16rx/d1 r16rx/d2 VDDIO VDDIO pfet L=0.25U W=1U
Mr16rx_Mln_f2 r16rx/d1 r16rx/d2 VDDIO VDDIO pfet L=0.25U W=1U
Mr16rx_Mln_f3 r16rx/d1 r16rx/d2 VDDIO VDDIO pfet L=0.25U W=1U
Mr16rx_Mi2p_f0 DOUT$16 r16rx/d1 VDDIO VDDIO pfet L=0.13U W=2U
Mr16rx_Mi2n_f0 DOUT$16 r16rx/d1 VSS VSS nfet L=0.13U W=1U
Dr17esd_Dp1 PAD$43 VDDIO diodevdd_mod A=35P P=58.08U
Dr17esd_Dp1_dsub VSS VDDIO dsub_2kv_mod A=224.956P P=81.12U
Mr17esd_Mn1_f0 PAD$43 VSS VSS VSS nfet L=0.13U W=2U
Mr17esd_Mn1_f1 PAD$43 VSS VSS VSS nfet L=0.13U W=2U
Mr17esd_Mn1_f2 PAD$43 VSS VSS VSS nfet L=0.13U W=2U
Mr17esd_Mn1_f3 PAD$43 VSS VSS VSS nfet L=0.13U W=2U
Mr17esd_Mn1_f4 PAD$43 VSS VSS VSS nfet L=0.13U W=2U
Mr17esd_Mn1_f5 PAD$43 VSS VSS VSS nfet L=0.13U W=2U
Mr17esd_Mn1_f6 PAD$43 VSS VSS VSS nfet L=0.13U W=2U
Mr17esd_Mn1_f7 PAD$43 VSS VSS VSS nfet L=0.13U W=2U
Mr17esd_Mn1_f8 PAD$43 VSS VSS VSS nfet L=0.13U W=2U
Mr17esd_Mn1_f9 PAD$43 VSS VSS VSS nfet L=0.13U W=2U
Mr17esd_Mclamp_f0 VDDIO VSS VSS VSS nfet L=0.35U W=2U
Mr17esd_Mclamp_f1 VDDIO VSS VSS VSS nfet L=0.35U W=2U
Mr17esd_Mclamp_f2 VDDIO VSS VSS VSS nfet L=0.35U W=2U
Mr17esd_Mclamp_f3 VDDIO VSS VSS VSS nfet L=0.35U W=2U
Mr17esd_Mclamp_f4 VDDIO VSS VSS VSS nfet L=0.35U W=2U
Mr17esd_Mclamp_f5 VDDIO VSS VSS VSS nfet L=0.35U W=2U
Mr17esd_Mclamp_f6 VDDIO VSS VSS VSS nfet L=0.35U W=2U
Mr17esd_Mclamp_f7 VDDIO VSS VSS VSS nfet L=0.35U W=2U
Mr17esd_Mclamp_f8 VDDIO VSS VSS VSS nfet L=0.35U W=2U
Mr17esd_Mclamp_f9 VDDIO VSS VSS VSS nfet L=0.35U W=2U
Mr17esd_Mclamp_f10 VDDIO VSS VSS VSS nfet L=0.35U W=2U
Mr17esd_Mclamp_f11 VDDIO VSS VSS VSS nfet L=0.35U W=2U
Mr17esd_Mclamp_f12 VDDIO VSS VSS VSS nfet L=0.35U W=2U
Mr17esd_Mclamp_f13 VDDIO VSS VSS VSS nfet L=0.35U W=2U
Mr17esd_Mclamp_f14 VDDIO VSS VSS VSS nfet L=0.35U W=2U
Mr17esd_Mclamp_f15 VDDIO VSS VSS VSS nfet L=0.35U W=2U
Mr17esd_Mclamp_f16 VDDIO VSS VSS VSS nfet L=0.35U W=2U
Mr17esd_Mclamp_f17 VDDIO VSS VSS VSS nfet L=0.35U W=2U
Mr17esd_Mclamp_f18 VDDIO VSS VSS VSS nfet L=0.35U W=2U
Mr17esd_Mclamp_f19 VDDIO VSS VSS VSS nfet L=0.35U W=2U
Xr17esd_Resd PAD$43 PADI_R17 VSS rppd r=164.6 L=1U W=2U
Dr17esd_Dp2 PADI_R17 VDDIO dpantenna A=4P P=8U
Mr17esd_Mn2_f0 PADI_R17 VSS VSS VSS nfet L=0.13U W=1U
Xr17rx_Rdiv1 VDDIO r17rx/vrn VSS rppd r=24804.0 L=48U W=0.5U
Xr17rx_Rdiv2 r17rx/vrn VSS VSS rppd r=24804.0 L=48U W=0.5U
Mr17rx_Mtail_f0 r17rx/s1 VDDIO VSS VSS nfet L=0.5U W=1U
Mr17rx_Mtail_f1 r17rx/s1 VDDIO VSS VSS nfet L=0.5U W=1U
Mr17rx_Mnp_f0 r17rx/d1 PADI_R17 r17rx/s1 VSS nfet L=0.5U W=0.5U
Mr17rx_Mnp_f1 r17rx/d1 PADI_R17 r17rx/s1 VSS nfet L=0.5U W=0.5U
Mr17rx_Mnn_f0 r17rx/d2 r17rx/vrn r17rx/s1 VSS nfet L=0.5U W=0.5U
Mr17rx_Mnn_f1 r17rx/d2 r17rx/vrn r17rx/s1 VSS nfet L=0.5U W=0.5U
Mr17rx_Mlp_f0 r17rx/d2 r17rx/d2 VDDIO VDDIO pfet L=0.25U W=1U
Mr17rx_Mlp_f1 r17rx/d2 r17rx/d2 VDDIO VDDIO pfet L=0.25U W=1U
Mr17rx_Mlp_f2 r17rx/d2 r17rx/d2 VDDIO VDDIO pfet L=0.25U W=1U
Mr17rx_Mlp_f3 r17rx/d2 r17rx/d2 VDDIO VDDIO pfet L=0.25U W=1U
Mr17rx_Mln_f0 r17rx/d1 r17rx/d2 VDDIO VDDIO pfet L=0.25U W=1U
Mr17rx_Mln_f1 r17rx/d1 r17rx/d2 VDDIO VDDIO pfet L=0.25U W=1U
Mr17rx_Mln_f2 r17rx/d1 r17rx/d2 VDDIO VDDIO pfet L=0.25U W=1U
Mr17rx_Mln_f3 r17rx/d1 r17rx/d2 VDDIO VDDIO pfet L=0.25U W=1U
Mr17rx_Mi2p_f0 DOUT$17 r17rx/d1 VDDIO VDDIO pfet L=0.13U W=2U
Mr17rx_Mi2n_f0 DOUT$17 r17rx/d1 VSS VSS nfet L=0.13U W=1U
Dr18esd_Dp1 PAD$44 VDDIO diodevdd_mod A=35P P=58.08U
Dr18esd_Dp1_dsub VSS VDDIO dsub_2kv_mod A=224.956P P=81.12U
Mr18esd_Mn1_f0 PAD$44 VSS VSS VSS nfet L=0.13U W=2U
Mr18esd_Mn1_f1 PAD$44 VSS VSS VSS nfet L=0.13U W=2U
Mr18esd_Mn1_f2 PAD$44 VSS VSS VSS nfet L=0.13U W=2U
Mr18esd_Mn1_f3 PAD$44 VSS VSS VSS nfet L=0.13U W=2U
Mr18esd_Mn1_f4 PAD$44 VSS VSS VSS nfet L=0.13U W=2U
Mr18esd_Mn1_f5 PAD$44 VSS VSS VSS nfet L=0.13U W=2U
Mr18esd_Mn1_f6 PAD$44 VSS VSS VSS nfet L=0.13U W=2U
Mr18esd_Mn1_f7 PAD$44 VSS VSS VSS nfet L=0.13U W=2U
Mr18esd_Mn1_f8 PAD$44 VSS VSS VSS nfet L=0.13U W=2U
Mr18esd_Mn1_f9 PAD$44 VSS VSS VSS nfet L=0.13U W=2U
Mr18esd_Mclamp_f0 VDDIO VSS VSS VSS nfet L=0.35U W=2U
Mr18esd_Mclamp_f1 VDDIO VSS VSS VSS nfet L=0.35U W=2U
Mr18esd_Mclamp_f2 VDDIO VSS VSS VSS nfet L=0.35U W=2U
Mr18esd_Mclamp_f3 VDDIO VSS VSS VSS nfet L=0.35U W=2U
Mr18esd_Mclamp_f4 VDDIO VSS VSS VSS nfet L=0.35U W=2U
Mr18esd_Mclamp_f5 VDDIO VSS VSS VSS nfet L=0.35U W=2U
Mr18esd_Mclamp_f6 VDDIO VSS VSS VSS nfet L=0.35U W=2U
Mr18esd_Mclamp_f7 VDDIO VSS VSS VSS nfet L=0.35U W=2U
Mr18esd_Mclamp_f8 VDDIO VSS VSS VSS nfet L=0.35U W=2U
Mr18esd_Mclamp_f9 VDDIO VSS VSS VSS nfet L=0.35U W=2U
Mr18esd_Mclamp_f10 VDDIO VSS VSS VSS nfet L=0.35U W=2U
Mr18esd_Mclamp_f11 VDDIO VSS VSS VSS nfet L=0.35U W=2U
Mr18esd_Mclamp_f12 VDDIO VSS VSS VSS nfet L=0.35U W=2U
Mr18esd_Mclamp_f13 VDDIO VSS VSS VSS nfet L=0.35U W=2U
Mr18esd_Mclamp_f14 VDDIO VSS VSS VSS nfet L=0.35U W=2U
Mr18esd_Mclamp_f15 VDDIO VSS VSS VSS nfet L=0.35U W=2U
Mr18esd_Mclamp_f16 VDDIO VSS VSS VSS nfet L=0.35U W=2U
Mr18esd_Mclamp_f17 VDDIO VSS VSS VSS nfet L=0.35U W=2U
Mr18esd_Mclamp_f18 VDDIO VSS VSS VSS nfet L=0.35U W=2U
Mr18esd_Mclamp_f19 VDDIO VSS VSS VSS nfet L=0.35U W=2U
Xr18esd_Resd PAD$44 PADI_R18 VSS rppd r=164.6 L=1U W=2U
Dr18esd_Dp2 PADI_R18 VDDIO dpantenna A=4P P=8U
Mr18esd_Mn2_f0 PADI_R18 VSS VSS VSS nfet L=0.13U W=1U
Xr18rx_Rdiv1 VDDIO r18rx/vrn VSS rppd r=24804.0 L=48U W=0.5U
Xr18rx_Rdiv2 r18rx/vrn VSS VSS rppd r=24804.0 L=48U W=0.5U
Mr18rx_Mtail_f0 r18rx/s1 VDDIO VSS VSS nfet L=0.5U W=1U
Mr18rx_Mtail_f1 r18rx/s1 VDDIO VSS VSS nfet L=0.5U W=1U
Mr18rx_Mnp_f0 r18rx/d1 PADI_R18 r18rx/s1 VSS nfet L=0.5U W=0.5U
Mr18rx_Mnp_f1 r18rx/d1 PADI_R18 r18rx/s1 VSS nfet L=0.5U W=0.5U
Mr18rx_Mnn_f0 r18rx/d2 r18rx/vrn r18rx/s1 VSS nfet L=0.5U W=0.5U
Mr18rx_Mnn_f1 r18rx/d2 r18rx/vrn r18rx/s1 VSS nfet L=0.5U W=0.5U
Mr18rx_Mlp_f0 r18rx/d2 r18rx/d2 VDDIO VDDIO pfet L=0.25U W=1U
Mr18rx_Mlp_f1 r18rx/d2 r18rx/d2 VDDIO VDDIO pfet L=0.25U W=1U
Mr18rx_Mlp_f2 r18rx/d2 r18rx/d2 VDDIO VDDIO pfet L=0.25U W=1U
Mr18rx_Mlp_f3 r18rx/d2 r18rx/d2 VDDIO VDDIO pfet L=0.25U W=1U
Mr18rx_Mln_f0 r18rx/d1 r18rx/d2 VDDIO VDDIO pfet L=0.25U W=1U
Mr18rx_Mln_f1 r18rx/d1 r18rx/d2 VDDIO VDDIO pfet L=0.25U W=1U
Mr18rx_Mln_f2 r18rx/d1 r18rx/d2 VDDIO VDDIO pfet L=0.25U W=1U
Mr18rx_Mln_f3 r18rx/d1 r18rx/d2 VDDIO VDDIO pfet L=0.25U W=1U
Mr18rx_Mi2p_f0 DOUT$18 r18rx/d1 VDDIO VDDIO pfet L=0.13U W=2U
Mr18rx_Mi2n_f0 DOUT$18 r18rx/d1 VSS VSS nfet L=0.13U W=1U
Dr19esd_Dp1 PAD$45 VDDIO diodevdd_mod A=35P P=58.08U
Dr19esd_Dp1_dsub VSS VDDIO dsub_2kv_mod A=224.956P P=81.12U
Mr19esd_Mn1_f0 PAD$45 VSS VSS VSS nfet L=0.13U W=2U
Mr19esd_Mn1_f1 PAD$45 VSS VSS VSS nfet L=0.13U W=2U
Mr19esd_Mn1_f2 PAD$45 VSS VSS VSS nfet L=0.13U W=2U
Mr19esd_Mn1_f3 PAD$45 VSS VSS VSS nfet L=0.13U W=2U
Mr19esd_Mn1_f4 PAD$45 VSS VSS VSS nfet L=0.13U W=2U
Mr19esd_Mn1_f5 PAD$45 VSS VSS VSS nfet L=0.13U W=2U
Mr19esd_Mn1_f6 PAD$45 VSS VSS VSS nfet L=0.13U W=2U
Mr19esd_Mn1_f7 PAD$45 VSS VSS VSS nfet L=0.13U W=2U
Mr19esd_Mn1_f8 PAD$45 VSS VSS VSS nfet L=0.13U W=2U
Mr19esd_Mn1_f9 PAD$45 VSS VSS VSS nfet L=0.13U W=2U
Mr19esd_Mclamp_f0 VDDIO VSS VSS VSS nfet L=0.35U W=2U
Mr19esd_Mclamp_f1 VDDIO VSS VSS VSS nfet L=0.35U W=2U
Mr19esd_Mclamp_f2 VDDIO VSS VSS VSS nfet L=0.35U W=2U
Mr19esd_Mclamp_f3 VDDIO VSS VSS VSS nfet L=0.35U W=2U
Mr19esd_Mclamp_f4 VDDIO VSS VSS VSS nfet L=0.35U W=2U
Mr19esd_Mclamp_f5 VDDIO VSS VSS VSS nfet L=0.35U W=2U
Mr19esd_Mclamp_f6 VDDIO VSS VSS VSS nfet L=0.35U W=2U
Mr19esd_Mclamp_f7 VDDIO VSS VSS VSS nfet L=0.35U W=2U
Mr19esd_Mclamp_f8 VDDIO VSS VSS VSS nfet L=0.35U W=2U
Mr19esd_Mclamp_f9 VDDIO VSS VSS VSS nfet L=0.35U W=2U
Mr19esd_Mclamp_f10 VDDIO VSS VSS VSS nfet L=0.35U W=2U
Mr19esd_Mclamp_f11 VDDIO VSS VSS VSS nfet L=0.35U W=2U
Mr19esd_Mclamp_f12 VDDIO VSS VSS VSS nfet L=0.35U W=2U
Mr19esd_Mclamp_f13 VDDIO VSS VSS VSS nfet L=0.35U W=2U
Mr19esd_Mclamp_f14 VDDIO VSS VSS VSS nfet L=0.35U W=2U
Mr19esd_Mclamp_f15 VDDIO VSS VSS VSS nfet L=0.35U W=2U
Mr19esd_Mclamp_f16 VDDIO VSS VSS VSS nfet L=0.35U W=2U
Mr19esd_Mclamp_f17 VDDIO VSS VSS VSS nfet L=0.35U W=2U
Mr19esd_Mclamp_f18 VDDIO VSS VSS VSS nfet L=0.35U W=2U
Mr19esd_Mclamp_f19 VDDIO VSS VSS VSS nfet L=0.35U W=2U
Xr19esd_Resd PAD$45 PADI_R19 VSS rppd r=164.6 L=1U W=2U
Dr19esd_Dp2 PADI_R19 VDDIO dpantenna A=4P P=8U
Mr19esd_Mn2_f0 PADI_R19 VSS VSS VSS nfet L=0.13U W=1U
Xr19rx_Rdiv1 VDDIO r19rx/vrn VSS rppd r=24804.0 L=48U W=0.5U
Xr19rx_Rdiv2 r19rx/vrn VSS VSS rppd r=24804.0 L=48U W=0.5U
Mr19rx_Mtail_f0 r19rx/s1 VDDIO VSS VSS nfet L=0.5U W=1U
Mr19rx_Mtail_f1 r19rx/s1 VDDIO VSS VSS nfet L=0.5U W=1U
Mr19rx_Mnp_f0 r19rx/d1 PADI_R19 r19rx/s1 VSS nfet L=0.5U W=0.5U
Mr19rx_Mnp_f1 r19rx/d1 PADI_R19 r19rx/s1 VSS nfet L=0.5U W=0.5U
Mr19rx_Mnn_f0 r19rx/d2 r19rx/vrn r19rx/s1 VSS nfet L=0.5U W=0.5U
Mr19rx_Mnn_f1 r19rx/d2 r19rx/vrn r19rx/s1 VSS nfet L=0.5U W=0.5U
Mr19rx_Mlp_f0 r19rx/d2 r19rx/d2 VDDIO VDDIO pfet L=0.25U W=1U
Mr19rx_Mlp_f1 r19rx/d2 r19rx/d2 VDDIO VDDIO pfet L=0.25U W=1U
Mr19rx_Mlp_f2 r19rx/d2 r19rx/d2 VDDIO VDDIO pfet L=0.25U W=1U
Mr19rx_Mlp_f3 r19rx/d2 r19rx/d2 VDDIO VDDIO pfet L=0.25U W=1U
Mr19rx_Mln_f0 r19rx/d1 r19rx/d2 VDDIO VDDIO pfet L=0.25U W=1U
Mr19rx_Mln_f1 r19rx/d1 r19rx/d2 VDDIO VDDIO pfet L=0.25U W=1U
Mr19rx_Mln_f2 r19rx/d1 r19rx/d2 VDDIO VDDIO pfet L=0.25U W=1U
Mr19rx_Mln_f3 r19rx/d1 r19rx/d2 VDDIO VDDIO pfet L=0.25U W=1U
Mr19rx_Mi2p_f0 DOUT$19 r19rx/d1 VDDIO VDDIO pfet L=0.13U W=2U
Mr19rx_Mi2n_f0 DOUT$19 r19rx/d1 VSS VSS nfet L=0.13U W=1U
Dr20esd_Dp1 PAD$46 VDDIO diodevdd_mod A=35P P=58.08U
Dr20esd_Dp1_dsub VSS VDDIO dsub_2kv_mod A=224.956P P=81.12U
Mr20esd_Mn1_f0 PAD$46 VSS VSS VSS nfet L=0.13U W=2U
Mr20esd_Mn1_f1 PAD$46 VSS VSS VSS nfet L=0.13U W=2U
Mr20esd_Mn1_f2 PAD$46 VSS VSS VSS nfet L=0.13U W=2U
Mr20esd_Mn1_f3 PAD$46 VSS VSS VSS nfet L=0.13U W=2U
Mr20esd_Mn1_f4 PAD$46 VSS VSS VSS nfet L=0.13U W=2U
Mr20esd_Mn1_f5 PAD$46 VSS VSS VSS nfet L=0.13U W=2U
Mr20esd_Mn1_f6 PAD$46 VSS VSS VSS nfet L=0.13U W=2U
Mr20esd_Mn1_f7 PAD$46 VSS VSS VSS nfet L=0.13U W=2U
Mr20esd_Mn1_f8 PAD$46 VSS VSS VSS nfet L=0.13U W=2U
Mr20esd_Mn1_f9 PAD$46 VSS VSS VSS nfet L=0.13U W=2U
Mr20esd_Mclamp_f0 VDDIO VSS VSS VSS nfet L=0.35U W=2U
Mr20esd_Mclamp_f1 VDDIO VSS VSS VSS nfet L=0.35U W=2U
Mr20esd_Mclamp_f2 VDDIO VSS VSS VSS nfet L=0.35U W=2U
Mr20esd_Mclamp_f3 VDDIO VSS VSS VSS nfet L=0.35U W=2U
Mr20esd_Mclamp_f4 VDDIO VSS VSS VSS nfet L=0.35U W=2U
Mr20esd_Mclamp_f5 VDDIO VSS VSS VSS nfet L=0.35U W=2U
Mr20esd_Mclamp_f6 VDDIO VSS VSS VSS nfet L=0.35U W=2U
Mr20esd_Mclamp_f7 VDDIO VSS VSS VSS nfet L=0.35U W=2U
Mr20esd_Mclamp_f8 VDDIO VSS VSS VSS nfet L=0.35U W=2U
Mr20esd_Mclamp_f9 VDDIO VSS VSS VSS nfet L=0.35U W=2U
Mr20esd_Mclamp_f10 VDDIO VSS VSS VSS nfet L=0.35U W=2U
Mr20esd_Mclamp_f11 VDDIO VSS VSS VSS nfet L=0.35U W=2U
Mr20esd_Mclamp_f12 VDDIO VSS VSS VSS nfet L=0.35U W=2U
Mr20esd_Mclamp_f13 VDDIO VSS VSS VSS nfet L=0.35U W=2U
Mr20esd_Mclamp_f14 VDDIO VSS VSS VSS nfet L=0.35U W=2U
Mr20esd_Mclamp_f15 VDDIO VSS VSS VSS nfet L=0.35U W=2U
Mr20esd_Mclamp_f16 VDDIO VSS VSS VSS nfet L=0.35U W=2U
Mr20esd_Mclamp_f17 VDDIO VSS VSS VSS nfet L=0.35U W=2U
Mr20esd_Mclamp_f18 VDDIO VSS VSS VSS nfet L=0.35U W=2U
Mr20esd_Mclamp_f19 VDDIO VSS VSS VSS nfet L=0.35U W=2U
Xr20esd_Resd PAD$46 PADI_R20 VSS rppd r=164.6 L=1U W=2U
Dr20esd_Dp2 PADI_R20 VDDIO dpantenna A=4P P=8U
Mr20esd_Mn2_f0 PADI_R20 VSS VSS VSS nfet L=0.13U W=1U
Xr20rx_Rdiv1 VDDIO r20rx/vrn VSS rppd r=24804.0 L=48U W=0.5U
Xr20rx_Rdiv2 r20rx/vrn VSS VSS rppd r=24804.0 L=48U W=0.5U
Mr20rx_Mtail_f0 r20rx/s1 VDDIO VSS VSS nfet L=0.5U W=1U
Mr20rx_Mtail_f1 r20rx/s1 VDDIO VSS VSS nfet L=0.5U W=1U
Mr20rx_Mnp_f0 r20rx/d1 PADI_R20 r20rx/s1 VSS nfet L=0.5U W=0.5U
Mr20rx_Mnp_f1 r20rx/d1 PADI_R20 r20rx/s1 VSS nfet L=0.5U W=0.5U
Mr20rx_Mnn_f0 r20rx/d2 r20rx/vrn r20rx/s1 VSS nfet L=0.5U W=0.5U
Mr20rx_Mnn_f1 r20rx/d2 r20rx/vrn r20rx/s1 VSS nfet L=0.5U W=0.5U
Mr20rx_Mlp_f0 r20rx/d2 r20rx/d2 VDDIO VDDIO pfet L=0.25U W=1U
Mr20rx_Mlp_f1 r20rx/d2 r20rx/d2 VDDIO VDDIO pfet L=0.25U W=1U
Mr20rx_Mlp_f2 r20rx/d2 r20rx/d2 VDDIO VDDIO pfet L=0.25U W=1U
Mr20rx_Mlp_f3 r20rx/d2 r20rx/d2 VDDIO VDDIO pfet L=0.25U W=1U
Mr20rx_Mln_f0 r20rx/d1 r20rx/d2 VDDIO VDDIO pfet L=0.25U W=1U
Mr20rx_Mln_f1 r20rx/d1 r20rx/d2 VDDIO VDDIO pfet L=0.25U W=1U
Mr20rx_Mln_f2 r20rx/d1 r20rx/d2 VDDIO VDDIO pfet L=0.25U W=1U
Mr20rx_Mln_f3 r20rx/d1 r20rx/d2 VDDIO VDDIO pfet L=0.25U W=1U
Mr20rx_Mi2p_f0 DOUT$20 r20rx/d1 VDDIO VDDIO pfet L=0.13U W=2U
Mr20rx_Mi2n_f0 DOUT$20 r20rx/d1 VSS VSS nfet L=0.13U W=1U
Dr21esd_Dp1 PAD$47 VDDIO diodevdd_mod A=35P P=58.08U
Dr21esd_Dp1_dsub VSS VDDIO dsub_2kv_mod A=224.956P P=81.12U
Mr21esd_Mn1_f0 PAD$47 VSS VSS VSS nfet L=0.13U W=2U
Mr21esd_Mn1_f1 PAD$47 VSS VSS VSS nfet L=0.13U W=2U
Mr21esd_Mn1_f2 PAD$47 VSS VSS VSS nfet L=0.13U W=2U
Mr21esd_Mn1_f3 PAD$47 VSS VSS VSS nfet L=0.13U W=2U
Mr21esd_Mn1_f4 PAD$47 VSS VSS VSS nfet L=0.13U W=2U
Mr21esd_Mn1_f5 PAD$47 VSS VSS VSS nfet L=0.13U W=2U
Mr21esd_Mn1_f6 PAD$47 VSS VSS VSS nfet L=0.13U W=2U
Mr21esd_Mn1_f7 PAD$47 VSS VSS VSS nfet L=0.13U W=2U
Mr21esd_Mn1_f8 PAD$47 VSS VSS VSS nfet L=0.13U W=2U
Mr21esd_Mn1_f9 PAD$47 VSS VSS VSS nfet L=0.13U W=2U
Mr21esd_Mclamp_f0 VDDIO VSS VSS VSS nfet L=0.35U W=2U
Mr21esd_Mclamp_f1 VDDIO VSS VSS VSS nfet L=0.35U W=2U
Mr21esd_Mclamp_f2 VDDIO VSS VSS VSS nfet L=0.35U W=2U
Mr21esd_Mclamp_f3 VDDIO VSS VSS VSS nfet L=0.35U W=2U
Mr21esd_Mclamp_f4 VDDIO VSS VSS VSS nfet L=0.35U W=2U
Mr21esd_Mclamp_f5 VDDIO VSS VSS VSS nfet L=0.35U W=2U
Mr21esd_Mclamp_f6 VDDIO VSS VSS VSS nfet L=0.35U W=2U
Mr21esd_Mclamp_f7 VDDIO VSS VSS VSS nfet L=0.35U W=2U
Mr21esd_Mclamp_f8 VDDIO VSS VSS VSS nfet L=0.35U W=2U
Mr21esd_Mclamp_f9 VDDIO VSS VSS VSS nfet L=0.35U W=2U
Mr21esd_Mclamp_f10 VDDIO VSS VSS VSS nfet L=0.35U W=2U
Mr21esd_Mclamp_f11 VDDIO VSS VSS VSS nfet L=0.35U W=2U
Mr21esd_Mclamp_f12 VDDIO VSS VSS VSS nfet L=0.35U W=2U
Mr21esd_Mclamp_f13 VDDIO VSS VSS VSS nfet L=0.35U W=2U
Mr21esd_Mclamp_f14 VDDIO VSS VSS VSS nfet L=0.35U W=2U
Mr21esd_Mclamp_f15 VDDIO VSS VSS VSS nfet L=0.35U W=2U
Mr21esd_Mclamp_f16 VDDIO VSS VSS VSS nfet L=0.35U W=2U
Mr21esd_Mclamp_f17 VDDIO VSS VSS VSS nfet L=0.35U W=2U
Mr21esd_Mclamp_f18 VDDIO VSS VSS VSS nfet L=0.35U W=2U
Mr21esd_Mclamp_f19 VDDIO VSS VSS VSS nfet L=0.35U W=2U
Xr21esd_Resd PAD$47 PADI_R21 VSS rppd r=164.6 L=1U W=2U
Dr21esd_Dp2 PADI_R21 VDDIO dpantenna A=4P P=8U
Mr21esd_Mn2_f0 PADI_R21 VSS VSS VSS nfet L=0.13U W=1U
Xr21rx_Rdiv1 VDDIO r21rx/vrn VSS rppd r=24804.0 L=48U W=0.5U
Xr21rx_Rdiv2 r21rx/vrn VSS VSS rppd r=24804.0 L=48U W=0.5U
Mr21rx_Mtail_f0 r21rx/s1 VDDIO VSS VSS nfet L=0.5U W=1U
Mr21rx_Mtail_f1 r21rx/s1 VDDIO VSS VSS nfet L=0.5U W=1U
Mr21rx_Mnp_f0 r21rx/d1 PADI_R21 r21rx/s1 VSS nfet L=0.5U W=0.5U
Mr21rx_Mnp_f1 r21rx/d1 PADI_R21 r21rx/s1 VSS nfet L=0.5U W=0.5U
Mr21rx_Mnn_f0 r21rx/d2 r21rx/vrn r21rx/s1 VSS nfet L=0.5U W=0.5U
Mr21rx_Mnn_f1 r21rx/d2 r21rx/vrn r21rx/s1 VSS nfet L=0.5U W=0.5U
Mr21rx_Mlp_f0 r21rx/d2 r21rx/d2 VDDIO VDDIO pfet L=0.25U W=1U
Mr21rx_Mlp_f1 r21rx/d2 r21rx/d2 VDDIO VDDIO pfet L=0.25U W=1U
Mr21rx_Mlp_f2 r21rx/d2 r21rx/d2 VDDIO VDDIO pfet L=0.25U W=1U
Mr21rx_Mlp_f3 r21rx/d2 r21rx/d2 VDDIO VDDIO pfet L=0.25U W=1U
Mr21rx_Mln_f0 r21rx/d1 r21rx/d2 VDDIO VDDIO pfet L=0.25U W=1U
Mr21rx_Mln_f1 r21rx/d1 r21rx/d2 VDDIO VDDIO pfet L=0.25U W=1U
Mr21rx_Mln_f2 r21rx/d1 r21rx/d2 VDDIO VDDIO pfet L=0.25U W=1U
Mr21rx_Mln_f3 r21rx/d1 r21rx/d2 VDDIO VDDIO pfet L=0.25U W=1U
Mr21rx_Mi2p_f0 DOUT$21 r21rx/d1 VDDIO VDDIO pfet L=0.13U W=2U
Mr21rx_Mi2n_f0 DOUT$21 r21rx/d1 VSS VSS nfet L=0.13U W=1U
Dr22esd_Dp1 PAD$25 VDDIO diodevdd_mod A=35P P=58.08U
Dr22esd_Dp1_dsub VSS VDDIO dsub_2kv_mod A=224.956P P=81.12U
Mr22esd_Mn1_f0 PAD$25 VSS VSS VSS nfet L=0.13U W=2U
Mr22esd_Mn1_f1 PAD$25 VSS VSS VSS nfet L=0.13U W=2U
Mr22esd_Mn1_f2 PAD$25 VSS VSS VSS nfet L=0.13U W=2U
Mr22esd_Mn1_f3 PAD$25 VSS VSS VSS nfet L=0.13U W=2U
Mr22esd_Mn1_f4 PAD$25 VSS VSS VSS nfet L=0.13U W=2U
Mr22esd_Mn1_f5 PAD$25 VSS VSS VSS nfet L=0.13U W=2U
Mr22esd_Mn1_f6 PAD$25 VSS VSS VSS nfet L=0.13U W=2U
Mr22esd_Mn1_f7 PAD$25 VSS VSS VSS nfet L=0.13U W=2U
Mr22esd_Mn1_f8 PAD$25 VSS VSS VSS nfet L=0.13U W=2U
Mr22esd_Mn1_f9 PAD$25 VSS VSS VSS nfet L=0.13U W=2U
Mr22esd_Mclamp_f0 VDDIO VSS VSS VSS nfet L=0.35U W=2U
Mr22esd_Mclamp_f1 VDDIO VSS VSS VSS nfet L=0.35U W=2U
Mr22esd_Mclamp_f2 VDDIO VSS VSS VSS nfet L=0.35U W=2U
Mr22esd_Mclamp_f3 VDDIO VSS VSS VSS nfet L=0.35U W=2U
Mr22esd_Mclamp_f4 VDDIO VSS VSS VSS nfet L=0.35U W=2U
Mr22esd_Mclamp_f5 VDDIO VSS VSS VSS nfet L=0.35U W=2U
Mr22esd_Mclamp_f6 VDDIO VSS VSS VSS nfet L=0.35U W=2U
Mr22esd_Mclamp_f7 VDDIO VSS VSS VSS nfet L=0.35U W=2U
Mr22esd_Mclamp_f8 VDDIO VSS VSS VSS nfet L=0.35U W=2U
Mr22esd_Mclamp_f9 VDDIO VSS VSS VSS nfet L=0.35U W=2U
Mr22esd_Mclamp_f10 VDDIO VSS VSS VSS nfet L=0.35U W=2U
Mr22esd_Mclamp_f11 VDDIO VSS VSS VSS nfet L=0.35U W=2U
Mr22esd_Mclamp_f12 VDDIO VSS VSS VSS nfet L=0.35U W=2U
Mr22esd_Mclamp_f13 VDDIO VSS VSS VSS nfet L=0.35U W=2U
Mr22esd_Mclamp_f14 VDDIO VSS VSS VSS nfet L=0.35U W=2U
Mr22esd_Mclamp_f15 VDDIO VSS VSS VSS nfet L=0.35U W=2U
Mr22esd_Mclamp_f16 VDDIO VSS VSS VSS nfet L=0.35U W=2U
Mr22esd_Mclamp_f17 VDDIO VSS VSS VSS nfet L=0.35U W=2U
Mr22esd_Mclamp_f18 VDDIO VSS VSS VSS nfet L=0.35U W=2U
Mr22esd_Mclamp_f19 VDDIO VSS VSS VSS nfet L=0.35U W=2U
Xr22esd_Resd PAD$25 PADI_R22 VSS rppd r=164.6 L=1U W=2U
Dr22esd_Dp2 PADI_R22 VDDIO dpantenna A=4P P=8U
Mr22esd_Mn2_f0 PADI_R22 VSS VSS VSS nfet L=0.13U W=1U
Mr22inv_Mi1p_f0 r22inv/M1 PADI_R22 VDDIO VDDIO pfet L=0.13U W=1.25U
Mr22inv_Mi1p_f1 r22inv/M1 PADI_R22 VDDIO VDDIO pfet L=0.13U W=1.25U
Mr22inv_Mi1n_f0 r22inv/M1 PADI_R22 VSS VSS nfet L=0.13U W=0.5U
Mr22inv_Mi1n_f1 r22inv/M1 PADI_R22 VSS VSS nfet L=0.13U W=0.5U
Mr22inv_Mi2p_f0 DOUT$22 r22inv/M1 VDDIO VDDIO pfet L=0.13U W=2U
Mr22inv_Mi2p_f1 DOUT$22 r22inv/M1 VDDIO VDDIO pfet L=0.13U W=2U
Mr22inv_Mi2n_f0 DOUT$22 r22inv/M1 VSS VSS nfet L=0.13U W=1U
Mr22inv_Mi2n_f1 DOUT$22 r22inv/M1 VSS VSS nfet L=0.13U W=1U
Dr23esd_Dp1 PAD$30 VDDIO diodevdd_mod A=35P P=58.08U
Dr23esd_Dp1_dsub VSS VDDIO dsub_2kv_mod A=224.956P P=81.12U
Mr23esd_Mn1_f0 PAD$30 VSS VSS VSS nfet L=0.13U W=2U
Mr23esd_Mn1_f1 PAD$30 VSS VSS VSS nfet L=0.13U W=2U
Mr23esd_Mn1_f2 PAD$30 VSS VSS VSS nfet L=0.13U W=2U
Mr23esd_Mn1_f3 PAD$30 VSS VSS VSS nfet L=0.13U W=2U
Mr23esd_Mn1_f4 PAD$30 VSS VSS VSS nfet L=0.13U W=2U
Mr23esd_Mn1_f5 PAD$30 VSS VSS VSS nfet L=0.13U W=2U
Mr23esd_Mn1_f6 PAD$30 VSS VSS VSS nfet L=0.13U W=2U
Mr23esd_Mn1_f7 PAD$30 VSS VSS VSS nfet L=0.13U W=2U
Mr23esd_Mn1_f8 PAD$30 VSS VSS VSS nfet L=0.13U W=2U
Mr23esd_Mn1_f9 PAD$30 VSS VSS VSS nfet L=0.13U W=2U
Mr23esd_Mclamp_f0 VDDIO VSS VSS VSS nfet L=0.35U W=2U
Mr23esd_Mclamp_f1 VDDIO VSS VSS VSS nfet L=0.35U W=2U
Mr23esd_Mclamp_f2 VDDIO VSS VSS VSS nfet L=0.35U W=2U
Mr23esd_Mclamp_f3 VDDIO VSS VSS VSS nfet L=0.35U W=2U
Mr23esd_Mclamp_f4 VDDIO VSS VSS VSS nfet L=0.35U W=2U
Mr23esd_Mclamp_f5 VDDIO VSS VSS VSS nfet L=0.35U W=2U
Mr23esd_Mclamp_f6 VDDIO VSS VSS VSS nfet L=0.35U W=2U
Mr23esd_Mclamp_f7 VDDIO VSS VSS VSS nfet L=0.35U W=2U
Mr23esd_Mclamp_f8 VDDIO VSS VSS VSS nfet L=0.35U W=2U
Mr23esd_Mclamp_f9 VDDIO VSS VSS VSS nfet L=0.35U W=2U
Mr23esd_Mclamp_f10 VDDIO VSS VSS VSS nfet L=0.35U W=2U
Mr23esd_Mclamp_f11 VDDIO VSS VSS VSS nfet L=0.35U W=2U
Mr23esd_Mclamp_f12 VDDIO VSS VSS VSS nfet L=0.35U W=2U
Mr23esd_Mclamp_f13 VDDIO VSS VSS VSS nfet L=0.35U W=2U
Mr23esd_Mclamp_f14 VDDIO VSS VSS VSS nfet L=0.35U W=2U
Mr23esd_Mclamp_f15 VDDIO VSS VSS VSS nfet L=0.35U W=2U
Mr23esd_Mclamp_f16 VDDIO VSS VSS VSS nfet L=0.35U W=2U
Mr23esd_Mclamp_f17 VDDIO VSS VSS VSS nfet L=0.35U W=2U
Mr23esd_Mclamp_f18 VDDIO VSS VSS VSS nfet L=0.35U W=2U
Mr23esd_Mclamp_f19 VDDIO VSS VSS VSS nfet L=0.35U W=2U
Xr23esd_Resd PAD$30 PADI_R23 VSS rppd r=164.6 L=1U W=2U
Dr23esd_Dp2 PADI_R23 VDDIO dpantenna A=4P P=8U
Mr23esd_Mn2_f0 PADI_R23 VSS VSS VSS nfet L=0.13U W=1U
Mr23inv_Mi1p_f0 r23inv/M1 PADI_R23 VDDIO VDDIO pfet L=0.13U W=1.25U
Mr23inv_Mi1p_f1 r23inv/M1 PADI_R23 VDDIO VDDIO pfet L=0.13U W=1.25U
Mr23inv_Mi1n_f0 r23inv/M1 PADI_R23 VSS VSS nfet L=0.13U W=0.5U
Mr23inv_Mi1n_f1 r23inv/M1 PADI_R23 VSS VSS nfet L=0.13U W=0.5U
Mr23inv_Mi2p_f0 DOUT$23 r23inv/M1 VDDIO VDDIO pfet L=0.13U W=2U
Mr23inv_Mi2p_f1 DOUT$23 r23inv/M1 VDDIO VDDIO pfet L=0.13U W=2U
Mr23inv_Mi2n_f0 DOUT$23 r23inv/M1 VSS VSS nfet L=0.13U W=1U
Mr23inv_Mi2n_f1 DOUT$23 r23inv/M1 VSS VSS nfet L=0.13U W=1U
.ENDS
