* Generated by layout/lvs/gen_reference.py -- DO NOT EDIT BY HAND.
* Plain-element form for `klt lvs`; flattened from the item 1 netlists:
*   design/aib_pad_esd.spice sha256:86d410385d099254f0376b9b4638cd18dfee8e7ae538a45e2ed85e2cdea415d5
*   design/aib_tx_data.spice sha256:adf7d751f8645148fe68be97b8d1ade38a2eadbf5432e05eed059c570850d2d7
*   design/aib_rx_data.spice sha256:43f326de980bc5a817d6235ab5402de4aa02886619ead25e7e60c41dfef99eab
*   design/aib_tx_clk.spice sha256:d2bdf119e914678106c566674093ccc54b75174d76592851cfd98db57dce32ad
*   design/aib_rx_clk.spice sha256:0e53de36f4d0d2585452746bb2cb5d35e7c8b0801cdf597efe1dbb7bc01b5b2d
.SUBCKT aib_io_column DIN DIN$1 DIN$2 DIN$3 DIN$4 DIN$5 DIN$6 DIN$7 DIN$8 DIN$9 DIN$10 DIN$11 DIN$12 DIN$13 DIN$14 DIN$15 DIN$16 DIN$17 DIN$18 DIN$19 DIN$20 DIN$21 DIN$22 DIN$23 DOUT DOUT$1 DOUT$2 DOUT$3 DOUT$4 DOUT$5 DOUT$6 DOUT$7 DOUT$8 DOUT$9 DOUT$10 DOUT$11 DOUT$12 DOUT$13 DOUT$14 DOUT$15 DOUT$16 DOUT$17 DOUT$18 DOUT$19 DOUT$20 DOUT$21 DOUT$22 DOUT$23 OE PAD PAD$1 PAD$2 PAD$3 PAD$4 PAD$5 PAD$6 PAD$7 PAD$8 PAD$9 PAD$10 PAD$11 PAD$12 PAD$13 PAD$14 PAD$15 PAD$16 PAD$17 PAD$18 PAD$19 PAD$20 PAD$21 PAD$22 PAD$23 PAD$24 PAD$25 PAD$26 PAD$27 PAD$28 PAD$29 PAD$30 PAD$31 PAD$32 PAD$33 PAD$34 PAD$35 PAD$36 PAD$37 PAD$38 PAD$39 PAD$40 PAD$41 PAD$42 PAD$43 PAD$44 PAD$45 PAD$46 PAD$47 PD PUN VDDIO VSS
Dt0esd_Dp1 PAD$1 VDDIO dpantenna A=100P P=40U
Dt0esd_Dn1 VSS PAD$1 dantenna A=100P P=40U
Mt0esd_Mclamp_f0 VDDIO VDDIO VSS VSS nfet L=0.35U W=2U
Mt0esd_Mclamp_f1 VDDIO VSS VSS VSS nfet L=0.35U W=2U
Mt0esd_Mclamp_f2 VDDIO VSS VSS VSS nfet L=0.35U W=2U
Mt0esd_Mclamp_f3 VDDIO VSS VSS VSS nfet L=0.35U W=2U
Mt0esd_Mclamp_f4 VDDIO VSS VSS VSS nfet L=0.35U W=2U
Mt0esd_Mclamp_f5 VDDIO VSS VSS VSS nfet L=0.35U W=2U
Mt0esd_Mclamp_f6 VDDIO VSS VSS VSS nfet L=0.35U W=2U
Mt0esd_Mclamp_f7 VDDIO VSS VSS VSS nfet L=0.35U W=2U
Mt0esd_Mclamp_f8 VDDIO VSS VSS VSS nfet L=0.35U W=2U
Mt0esd_Mclamp_f9 VDDIO VSS VSS VSS nfet L=0.35U W=2U
Mt0esd_Mclamp_f10 VDDIO VSS VSS VSS nfet L=0.35U W=2U
Mt0esd_Mclamp_f11 VDDIO VSS VSS VSS nfet L=0.35U W=2U
Mt0esd_Mclamp_f12 VDDIO VSS VSS VSS nfet L=0.35U W=2U
Mt0esd_Mclamp_f13 VDDIO VSS VSS VSS nfet L=0.35U W=2U
Mt0esd_Mclamp_f14 VDDIO VSS VSS VSS nfet L=0.35U W=2U
Mt0esd_Mclamp_f15 VDDIO VSS VSS VSS nfet L=0.35U W=2U
Mt0esd_Mclamp_f16 VDDIO VSS VSS VSS nfet L=0.35U W=2U
Mt0esd_Mclamp_f17 VDDIO VSS VSS VSS nfet L=0.35U W=2U
Mt0esd_Mclamp_f18 VDDIO VSS VSS VSS nfet L=0.35U W=2U
Mt0esd_Mclamp_f19 VDDIO VSS VSS VSS nfet L=0.35U W=2U
Xt0esd_Resd PAD$1 PADI_T0 VSS rppd r=294.2 L=2U W=2U
Dt0esd_Dp2 PADI_T0 VDDIO dpantenna A=4P P=8U
Mt0esd_Mn2_f0 PADI_T0 VSS VSS VSS nfet L=0.13U W=1U
Mt0tx_Mi1p_f0 t0tx/OEB OE VDDIO VDDIO pfet L=0.13U W=2U
Mt0tx_Mi1n_f0 t0tx/OEB OE VSS VSS nfet L=0.13U W=1U
Mt0tx_Mnd1p_f0 t0tx/GP DIN VDDIO VDDIO pfet L=0.13U W=2U
Mt0tx_Mnd1p_f1 t0tx/GP DIN VDDIO VDDIO pfet L=0.13U W=2U
Mt0tx_Mnd2p_f0 t0tx/GP OE VDDIO VDDIO pfet L=0.13U W=2U
Mt0tx_Mnd2p_f1 t0tx/GP OE VDDIO VDDIO pfet L=0.13U W=2U
Mt0tx_Mnd1n_f0 t0tx/GP DIN t0tx/NA VSS nfet L=0.13U W=2U
Mt0tx_Mnd1n_f1 t0tx/GP DIN t0tx/NA VSS nfet L=0.13U W=2U
Mt0tx_Mnd2n_f0 t0tx/NA OE VSS VSS nfet L=0.13U W=2U
Mt0tx_Mnd2n_f1 t0tx/NA OE VSS VSS nfet L=0.13U W=2U
Mt0tx_Mnr1p_f0 t0tx/NB DIN VDDIO VDDIO pfet L=0.13U W=2U
Mt0tx_Mnr1p_f1 t0tx/NB DIN VDDIO VDDIO pfet L=0.13U W=2U
Mt0tx_Mnr2p_f0 t0tx/GN t0tx/OEB t0tx/NB VDDIO pfet L=0.13U W=2U
Mt0tx_Mnr2p_f1 t0tx/GN t0tx/OEB t0tx/NB VDDIO pfet L=0.13U W=2U
Mt0tx_Mnr1n_f0 t0tx/GN DIN VSS VSS nfet L=0.13U W=1U
Mt0tx_Mnr1n_f1 t0tx/GN DIN VSS VSS nfet L=0.13U W=1U
Mt0tx_Mnr2n_f0 t0tx/GN t0tx/OEB VSS VSS nfet L=0.13U W=1U
Mt0tx_Mnr2n_f1 t0tx/GN t0tx/OEB VSS VSS nfet L=0.13U W=1U
Mt0tx_Mp_f0 PAD$1 t0tx/GP VDDIO VDDIO pfet L=0.13U W=1U
Mt0tx_Mp_f1 PAD$1 t0tx/GP VDDIO VDDIO pfet L=0.13U W=1U
Mt0tx_Mp_f2 PAD$1 t0tx/GP VDDIO VDDIO pfet L=0.13U W=1U
Mt0tx_Mp_f3 PAD$1 t0tx/GP VDDIO VDDIO pfet L=0.13U W=1U
Mt0tx_Mp_f4 PAD$1 t0tx/GP VDDIO VDDIO pfet L=0.13U W=1U
Mt0tx_Mp_f5 PAD$1 t0tx/GP VDDIO VDDIO pfet L=0.13U W=1U
Mt0tx_Mp_f6 PAD$1 t0tx/GP VDDIO VDDIO pfet L=0.13U W=1U
Mt0tx_Mp_f7 PAD$1 t0tx/GP VDDIO VDDIO pfet L=0.13U W=1U
Mt0tx_Mp_f8 PAD$1 t0tx/GP VDDIO VDDIO pfet L=0.13U W=1U
Mt0tx_Mp_f9 PAD$1 t0tx/GP VDDIO VDDIO pfet L=0.13U W=1U
Mt0tx_Mp_f10 PAD$1 t0tx/GP VDDIO VDDIO pfet L=0.13U W=1U
Mt0tx_Mp_f11 PAD$1 t0tx/GP VDDIO VDDIO pfet L=0.13U W=1U
Mt0tx_Mp_f12 PAD$1 t0tx/GP VDDIO VDDIO pfet L=0.13U W=1U
Mt0tx_Mp_f13 PAD$1 t0tx/GP VDDIO VDDIO pfet L=0.13U W=1U
Mt0tx_Mp_f14 PAD$1 t0tx/GP VDDIO VDDIO pfet L=0.13U W=1U
Mt0tx_Mp_f15 PAD$1 t0tx/GP VDDIO VDDIO pfet L=0.13U W=1U
Mt0tx_Mp_f16 PAD$1 t0tx/GP VDDIO VDDIO pfet L=0.13U W=1U
Mt0tx_Mp_f17 PAD$1 t0tx/GP VDDIO VDDIO pfet L=0.13U W=1U
Mt0tx_Mp_f18 PAD$1 t0tx/GP VDDIO VDDIO pfet L=0.13U W=1U
Mt0tx_Mp_f19 PAD$1 t0tx/GP VDDIO VDDIO pfet L=0.13U W=1U
Mt0tx_Mp_f20 PAD$1 t0tx/GP VDDIO VDDIO pfet L=0.13U W=1U
Mt0tx_Mp_f21 PAD$1 t0tx/GP VDDIO VDDIO pfet L=0.13U W=1U
Mt0tx_Mp_f22 PAD$1 t0tx/GP VDDIO VDDIO pfet L=0.13U W=1U
Mt0tx_Mp_f23 PAD$1 t0tx/GP VDDIO VDDIO pfet L=0.13U W=1U
Mt0tx_Mp_f24 PAD$1 t0tx/GP VDDIO VDDIO pfet L=0.13U W=1U
Mt0tx_Mp_f25 PAD$1 t0tx/GP VDDIO VDDIO pfet L=0.13U W=1U
Mt0tx_Mp_f26 PAD$1 t0tx/GP VDDIO VDDIO pfet L=0.13U W=1U
Mt0tx_Mp_f27 PAD$1 t0tx/GP VDDIO VDDIO pfet L=0.13U W=1U
Mt0tx_Mn_f0 PAD$1 t0tx/GN VSS VSS nfet L=0.13U W=1U
Mt0tx_Mn_f1 PAD$1 t0tx/GN VSS VSS nfet L=0.13U W=1U
Mt0tx_Mn_f2 PAD$1 t0tx/GN VSS VSS nfet L=0.13U W=1U
Mt0tx_Mn_f3 PAD$1 t0tx/GN VSS VSS nfet L=0.13U W=1U
Mt0tx_Mn_f4 PAD$1 t0tx/GN VSS VSS nfet L=0.13U W=1U
Mt0tx_Mn_f5 PAD$1 t0tx/GN VSS VSS nfet L=0.13U W=1U
Mt0tx_Mn_f6 PAD$1 t0tx/GN VSS VSS nfet L=0.13U W=1U
Mt0tx_Mn_f7 PAD$1 t0tx/GN VSS VSS nfet L=0.13U W=1U
Mt0tx_Mn_f8 PAD$1 t0tx/GN VSS VSS nfet L=0.13U W=1U
Mt0tx_Mn_f9 PAD$1 t0tx/GN VSS VSS nfet L=0.13U W=1U
Mt0tx_Mn_f10 PAD$1 t0tx/GN VSS VSS nfet L=0.13U W=1U
Mt0tx_Mn_f11 PAD$1 t0tx/GN VSS VSS nfet L=0.13U W=1U
Mt0tx_Mn_f12 PAD$1 t0tx/GN VSS VSS nfet L=0.13U W=1U
Mt0tx_Mn_f13 PAD$1 t0tx/GN VSS VSS nfet L=0.13U W=1U
Mt0tx_Mpu_f0 t0tx/PUX PUN VDDIO VDDIO pfet L=0.13U W=2U
Xt0tx_Rpu t0tx/PUX PAD$1 VSS rppd r=12472.0 L=24U W=0.5U
Mt0tx_Mpd_f0 t0tx/PDX PD VSS VSS nfet L=0.13U W=1U
Xt0tx_Rpd PAD$1 t0tx/PDX VSS rppd r=12472.0 L=24U W=0.5U
Dt1esd_Dp1 PAD$3 VDDIO dpantenna A=100P P=40U
Dt1esd_Dn1 VSS PAD$3 dantenna A=100P P=40U
Mt1esd_Mclamp_f0 VDDIO VSS VSS VSS nfet L=0.35U W=2U
Mt1esd_Mclamp_f1 VDDIO VSS VSS VSS nfet L=0.35U W=2U
Mt1esd_Mclamp_f2 VDDIO VSS VSS VSS nfet L=0.35U W=2U
Mt1esd_Mclamp_f3 VDDIO VSS VSS VSS nfet L=0.35U W=2U
Mt1esd_Mclamp_f4 VDDIO VSS VSS VSS nfet L=0.35U W=2U
Mt1esd_Mclamp_f5 VDDIO VSS VSS VSS nfet L=0.35U W=2U
Mt1esd_Mclamp_f6 VDDIO VSS VSS VSS nfet L=0.35U W=2U
Mt1esd_Mclamp_f7 VDDIO VSS VSS VSS nfet L=0.35U W=2U
Mt1esd_Mclamp_f8 VDDIO VSS VSS VSS nfet L=0.35U W=2U
Mt1esd_Mclamp_f9 VDDIO VSS VSS VSS nfet L=0.35U W=2U
Mt1esd_Mclamp_f10 VDDIO VSS VSS VSS nfet L=0.35U W=2U
Mt1esd_Mclamp_f11 VDDIO VSS VSS VSS nfet L=0.35U W=2U
Mt1esd_Mclamp_f12 VDDIO VSS VSS VSS nfet L=0.35U W=2U
Mt1esd_Mclamp_f13 VDDIO VSS VSS VSS nfet L=0.35U W=2U
Mt1esd_Mclamp_f14 VDDIO VSS VSS VSS nfet L=0.35U W=2U
Mt1esd_Mclamp_f15 VDDIO VSS VSS VSS nfet L=0.35U W=2U
Mt1esd_Mclamp_f16 VDDIO VSS VSS VSS nfet L=0.35U W=2U
Mt1esd_Mclamp_f17 VDDIO VSS VSS VSS nfet L=0.35U W=2U
Mt1esd_Mclamp_f18 VDDIO VSS VSS VSS nfet L=0.35U W=2U
Mt1esd_Mclamp_f19 VDDIO VSS VSS VSS nfet L=0.35U W=2U
Xt1esd_Resd PAD$3 PADI_T1 VSS rppd r=294.2 L=2U W=2U
Dt1esd_Dp2 PADI_T1 VDDIO dpantenna A=4P P=8U
Mt1esd_Mn2_f0 PADI_T1 VSS VSS VSS nfet L=0.13U W=1U
Mt1tx_Mi1p_f0 t1tx/OEB OE VDDIO VDDIO pfet L=0.13U W=2U
Mt1tx_Mi1n_f0 t1tx/OEB OE VSS VSS nfet L=0.13U W=1U
Mt1tx_Mnd1p_f0 t1tx/GP DIN$1 VDDIO VDDIO pfet L=0.13U W=2U
Mt1tx_Mnd1p_f1 t1tx/GP DIN$1 VDDIO VDDIO pfet L=0.13U W=2U
Mt1tx_Mnd2p_f0 t1tx/GP OE VDDIO VDDIO pfet L=0.13U W=2U
Mt1tx_Mnd2p_f1 t1tx/GP OE VDDIO VDDIO pfet L=0.13U W=2U
Mt1tx_Mnd1n_f0 t1tx/GP DIN$1 t1tx/NA VSS nfet L=0.13U W=2U
Mt1tx_Mnd1n_f1 t1tx/GP DIN$1 t1tx/NA VSS nfet L=0.13U W=2U
Mt1tx_Mnd2n_f0 t1tx/NA OE VSS VSS nfet L=0.13U W=2U
Mt1tx_Mnd2n_f1 t1tx/NA OE VSS VSS nfet L=0.13U W=2U
Mt1tx_Mnr1p_f0 t1tx/NB DIN$1 VDDIO VDDIO pfet L=0.13U W=2U
Mt1tx_Mnr1p_f1 t1tx/NB DIN$1 VDDIO VDDIO pfet L=0.13U W=2U
Mt1tx_Mnr2p_f0 t1tx/GN t1tx/OEB t1tx/NB VDDIO pfet L=0.13U W=2U
Mt1tx_Mnr2p_f1 t1tx/GN t1tx/OEB t1tx/NB VDDIO pfet L=0.13U W=2U
Mt1tx_Mnr1n_f0 t1tx/GN DIN$1 VSS VSS nfet L=0.13U W=1U
Mt1tx_Mnr1n_f1 t1tx/GN DIN$1 VSS VSS nfet L=0.13U W=1U
Mt1tx_Mnr2n_f0 t1tx/GN t1tx/OEB VSS VSS nfet L=0.13U W=1U
Mt1tx_Mnr2n_f1 t1tx/GN t1tx/OEB VSS VSS nfet L=0.13U W=1U
Mt1tx_Mp_f0 PAD$3 t1tx/GP VDDIO VDDIO pfet L=0.13U W=1U
Mt1tx_Mp_f1 PAD$3 t1tx/GP VDDIO VDDIO pfet L=0.13U W=1U
Mt1tx_Mp_f2 PAD$3 t1tx/GP VDDIO VDDIO pfet L=0.13U W=1U
Mt1tx_Mp_f3 PAD$3 t1tx/GP VDDIO VDDIO pfet L=0.13U W=1U
Mt1tx_Mp_f4 PAD$3 t1tx/GP VDDIO VDDIO pfet L=0.13U W=1U
Mt1tx_Mp_f5 PAD$3 t1tx/GP VDDIO VDDIO pfet L=0.13U W=1U
Mt1tx_Mp_f6 PAD$3 t1tx/GP VDDIO VDDIO pfet L=0.13U W=1U
Mt1tx_Mp_f7 PAD$3 t1tx/GP VDDIO VDDIO pfet L=0.13U W=1U
Mt1tx_Mp_f8 PAD$3 t1tx/GP VDDIO VDDIO pfet L=0.13U W=1U
Mt1tx_Mp_f9 PAD$3 t1tx/GP VDDIO VDDIO pfet L=0.13U W=1U
Mt1tx_Mp_f10 PAD$3 t1tx/GP VDDIO VDDIO pfet L=0.13U W=1U
Mt1tx_Mp_f11 PAD$3 t1tx/GP VDDIO VDDIO pfet L=0.13U W=1U
Mt1tx_Mp_f12 PAD$3 t1tx/GP VDDIO VDDIO pfet L=0.13U W=1U
Mt1tx_Mp_f13 PAD$3 t1tx/GP VDDIO VDDIO pfet L=0.13U W=1U
Mt1tx_Mp_f14 PAD$3 t1tx/GP VDDIO VDDIO pfet L=0.13U W=1U
Mt1tx_Mp_f15 PAD$3 t1tx/GP VDDIO VDDIO pfet L=0.13U W=1U
Mt1tx_Mp_f16 PAD$3 t1tx/GP VDDIO VDDIO pfet L=0.13U W=1U
Mt1tx_Mp_f17 PAD$3 t1tx/GP VDDIO VDDIO pfet L=0.13U W=1U
Mt1tx_Mp_f18 PAD$3 t1tx/GP VDDIO VDDIO pfet L=0.13U W=1U
Mt1tx_Mp_f19 PAD$3 t1tx/GP VDDIO VDDIO pfet L=0.13U W=1U
Mt1tx_Mp_f20 PAD$3 t1tx/GP VDDIO VDDIO pfet L=0.13U W=1U
Mt1tx_Mp_f21 PAD$3 t1tx/GP VDDIO VDDIO pfet L=0.13U W=1U
Mt1tx_Mp_f22 PAD$3 t1tx/GP VDDIO VDDIO pfet L=0.13U W=1U
Mt1tx_Mp_f23 PAD$3 t1tx/GP VDDIO VDDIO pfet L=0.13U W=1U
Mt1tx_Mp_f24 PAD$3 t1tx/GP VDDIO VDDIO pfet L=0.13U W=1U
Mt1tx_Mp_f25 PAD$3 t1tx/GP VDDIO VDDIO pfet L=0.13U W=1U
Mt1tx_Mp_f26 PAD$3 t1tx/GP VDDIO VDDIO pfet L=0.13U W=1U
Mt1tx_Mp_f27 PAD$3 t1tx/GP VDDIO VDDIO pfet L=0.13U W=1U
Mt1tx_Mn_f0 PAD$3 t1tx/GN VSS VSS nfet L=0.13U W=1U
Mt1tx_Mn_f1 PAD$3 t1tx/GN VSS VSS nfet L=0.13U W=1U
Mt1tx_Mn_f2 PAD$3 t1tx/GN VSS VSS nfet L=0.13U W=1U
Mt1tx_Mn_f3 PAD$3 t1tx/GN VSS VSS nfet L=0.13U W=1U
Mt1tx_Mn_f4 PAD$3 t1tx/GN VSS VSS nfet L=0.13U W=1U
Mt1tx_Mn_f5 PAD$3 t1tx/GN VSS VSS nfet L=0.13U W=1U
Mt1tx_Mn_f6 PAD$3 t1tx/GN VSS VSS nfet L=0.13U W=1U
Mt1tx_Mn_f7 PAD$3 t1tx/GN VSS VSS nfet L=0.13U W=1U
Mt1tx_Mn_f8 PAD$3 t1tx/GN VSS VSS nfet L=0.13U W=1U
Mt1tx_Mn_f9 PAD$3 t1tx/GN VSS VSS nfet L=0.13U W=1U
Mt1tx_Mn_f10 PAD$3 t1tx/GN VSS VSS nfet L=0.13U W=1U
Mt1tx_Mn_f11 PAD$3 t1tx/GN VSS VSS nfet L=0.13U W=1U
Mt1tx_Mn_f12 PAD$3 t1tx/GN VSS VSS nfet L=0.13U W=1U
Mt1tx_Mn_f13 PAD$3 t1tx/GN VSS VSS nfet L=0.13U W=1U
Mt1tx_Mpu_f0 t1tx/PUX PUN VDDIO VDDIO pfet L=0.13U W=2U
Xt1tx_Rpu t1tx/PUX PAD$3 VSS rppd r=12472.0 L=24U W=0.5U
Mt1tx_Mpd_f0 t1tx/PDX PD VSS VSS nfet L=0.13U W=1U
Xt1tx_Rpd PAD$3 t1tx/PDX VSS rppd r=12472.0 L=24U W=0.5U
Dt2esd_Dp1 PAD$5 VDDIO dpantenna A=100P P=40U
Dt2esd_Dn1 VSS PAD$5 dantenna A=100P P=40U
Mt2esd_Mclamp_f0 VDDIO VSS VSS VSS nfet L=0.35U W=2U
Mt2esd_Mclamp_f1 VDDIO VSS VSS VSS nfet L=0.35U W=2U
Mt2esd_Mclamp_f2 VDDIO VSS VSS VSS nfet L=0.35U W=2U
Mt2esd_Mclamp_f3 VDDIO VSS VSS VSS nfet L=0.35U W=2U
Mt2esd_Mclamp_f4 VDDIO VSS VSS VSS nfet L=0.35U W=2U
Mt2esd_Mclamp_f5 VDDIO VSS VSS VSS nfet L=0.35U W=2U
Mt2esd_Mclamp_f6 VDDIO VSS VSS VSS nfet L=0.35U W=2U
Mt2esd_Mclamp_f7 VDDIO VSS VSS VSS nfet L=0.35U W=2U
Mt2esd_Mclamp_f8 VDDIO VSS VSS VSS nfet L=0.35U W=2U
Mt2esd_Mclamp_f9 VDDIO VSS VSS VSS nfet L=0.35U W=2U
Mt2esd_Mclamp_f10 VDDIO VSS VSS VSS nfet L=0.35U W=2U
Mt2esd_Mclamp_f11 VDDIO VSS VSS VSS nfet L=0.35U W=2U
Mt2esd_Mclamp_f12 VDDIO VSS VSS VSS nfet L=0.35U W=2U
Mt2esd_Mclamp_f13 VDDIO VSS VSS VSS nfet L=0.35U W=2U
Mt2esd_Mclamp_f14 VDDIO VSS VSS VSS nfet L=0.35U W=2U
Mt2esd_Mclamp_f15 VDDIO VSS VSS VSS nfet L=0.35U W=2U
Mt2esd_Mclamp_f16 VDDIO VSS VSS VSS nfet L=0.35U W=2U
Mt2esd_Mclamp_f17 VDDIO VSS VSS VSS nfet L=0.35U W=2U
Mt2esd_Mclamp_f18 VDDIO VSS VSS VSS nfet L=0.35U W=2U
Mt2esd_Mclamp_f19 VDDIO VSS VSS VSS nfet L=0.35U W=2U
Xt2esd_Resd PAD$5 PADI_T2 VSS rppd r=294.2 L=2U W=2U
Dt2esd_Dp2 PADI_T2 VDDIO dpantenna A=4P P=8U
Mt2esd_Mn2_f0 PADI_T2 VSS VSS VSS nfet L=0.13U W=1U
Mt2tx_Mi1p_f0 t2tx/OEB OE VDDIO VDDIO pfet L=0.13U W=2U
Mt2tx_Mi1n_f0 t2tx/OEB OE VSS VSS nfet L=0.13U W=1U
Mt2tx_Mnd1p_f0 t2tx/GP DIN$2 VDDIO VDDIO pfet L=0.13U W=2U
Mt2tx_Mnd1p_f1 t2tx/GP DIN$2 VDDIO VDDIO pfet L=0.13U W=2U
Mt2tx_Mnd2p_f0 t2tx/GP OE VDDIO VDDIO pfet L=0.13U W=2U
Mt2tx_Mnd2p_f1 t2tx/GP OE VDDIO VDDIO pfet L=0.13U W=2U
Mt2tx_Mnd1n_f0 t2tx/GP DIN$2 t2tx/NA VSS nfet L=0.13U W=2U
Mt2tx_Mnd1n_f1 t2tx/GP DIN$2 t2tx/NA VSS nfet L=0.13U W=2U
Mt2tx_Mnd2n_f0 t2tx/NA OE VSS VSS nfet L=0.13U W=2U
Mt2tx_Mnd2n_f1 t2tx/NA OE VSS VSS nfet L=0.13U W=2U
Mt2tx_Mnr1p_f0 t2tx/NB DIN$2 VDDIO VDDIO pfet L=0.13U W=2U
Mt2tx_Mnr1p_f1 t2tx/NB DIN$2 VDDIO VDDIO pfet L=0.13U W=2U
Mt2tx_Mnr2p_f0 t2tx/GN t2tx/OEB t2tx/NB VDDIO pfet L=0.13U W=2U
Mt2tx_Mnr2p_f1 t2tx/GN t2tx/OEB t2tx/NB VDDIO pfet L=0.13U W=2U
Mt2tx_Mnr1n_f0 t2tx/GN DIN$2 VSS VSS nfet L=0.13U W=1U
Mt2tx_Mnr1n_f1 t2tx/GN DIN$2 VSS VSS nfet L=0.13U W=1U
Mt2tx_Mnr2n_f0 t2tx/GN t2tx/OEB VSS VSS nfet L=0.13U W=1U
Mt2tx_Mnr2n_f1 t2tx/GN t2tx/OEB VSS VSS nfet L=0.13U W=1U
Mt2tx_Mp_f0 PAD$5 t2tx/GP VDDIO VDDIO pfet L=0.13U W=1U
Mt2tx_Mp_f1 PAD$5 t2tx/GP VDDIO VDDIO pfet L=0.13U W=1U
Mt2tx_Mp_f2 PAD$5 t2tx/GP VDDIO VDDIO pfet L=0.13U W=1U
Mt2tx_Mp_f3 PAD$5 t2tx/GP VDDIO VDDIO pfet L=0.13U W=1U
Mt2tx_Mp_f4 PAD$5 t2tx/GP VDDIO VDDIO pfet L=0.13U W=1U
Mt2tx_Mp_f5 PAD$5 t2tx/GP VDDIO VDDIO pfet L=0.13U W=1U
Mt2tx_Mp_f6 PAD$5 t2tx/GP VDDIO VDDIO pfet L=0.13U W=1U
Mt2tx_Mp_f7 PAD$5 t2tx/GP VDDIO VDDIO pfet L=0.13U W=1U
Mt2tx_Mp_f8 PAD$5 t2tx/GP VDDIO VDDIO pfet L=0.13U W=1U
Mt2tx_Mp_f9 PAD$5 t2tx/GP VDDIO VDDIO pfet L=0.13U W=1U
Mt2tx_Mp_f10 PAD$5 t2tx/GP VDDIO VDDIO pfet L=0.13U W=1U
Mt2tx_Mp_f11 PAD$5 t2tx/GP VDDIO VDDIO pfet L=0.13U W=1U
Mt2tx_Mp_f12 PAD$5 t2tx/GP VDDIO VDDIO pfet L=0.13U W=1U
Mt2tx_Mp_f13 PAD$5 t2tx/GP VDDIO VDDIO pfet L=0.13U W=1U
Mt2tx_Mp_f14 PAD$5 t2tx/GP VDDIO VDDIO pfet L=0.13U W=1U
Mt2tx_Mp_f15 PAD$5 t2tx/GP VDDIO VDDIO pfet L=0.13U W=1U
Mt2tx_Mp_f16 PAD$5 t2tx/GP VDDIO VDDIO pfet L=0.13U W=1U
Mt2tx_Mp_f17 PAD$5 t2tx/GP VDDIO VDDIO pfet L=0.13U W=1U
Mt2tx_Mp_f18 PAD$5 t2tx/GP VDDIO VDDIO pfet L=0.13U W=1U
Mt2tx_Mp_f19 PAD$5 t2tx/GP VDDIO VDDIO pfet L=0.13U W=1U
Mt2tx_Mp_f20 PAD$5 t2tx/GP VDDIO VDDIO pfet L=0.13U W=1U
Mt2tx_Mp_f21 PAD$5 t2tx/GP VDDIO VDDIO pfet L=0.13U W=1U
Mt2tx_Mp_f22 PAD$5 t2tx/GP VDDIO VDDIO pfet L=0.13U W=1U
Mt2tx_Mp_f23 PAD$5 t2tx/GP VDDIO VDDIO pfet L=0.13U W=1U
Mt2tx_Mp_f24 PAD$5 t2tx/GP VDDIO VDDIO pfet L=0.13U W=1U
Mt2tx_Mp_f25 PAD$5 t2tx/GP VDDIO VDDIO pfet L=0.13U W=1U
Mt2tx_Mp_f26 PAD$5 t2tx/GP VDDIO VDDIO pfet L=0.13U W=1U
Mt2tx_Mp_f27 PAD$5 t2tx/GP VDDIO VDDIO pfet L=0.13U W=1U
Mt2tx_Mn_f0 PAD$5 t2tx/GN VSS VSS nfet L=0.13U W=1U
Mt2tx_Mn_f1 PAD$5 t2tx/GN VSS VSS nfet L=0.13U W=1U
Mt2tx_Mn_f2 PAD$5 t2tx/GN VSS VSS nfet L=0.13U W=1U
Mt2tx_Mn_f3 PAD$5 t2tx/GN VSS VSS nfet L=0.13U W=1U
Mt2tx_Mn_f4 PAD$5 t2tx/GN VSS VSS nfet L=0.13U W=1U
Mt2tx_Mn_f5 PAD$5 t2tx/GN VSS VSS nfet L=0.13U W=1U
Mt2tx_Mn_f6 PAD$5 t2tx/GN VSS VSS nfet L=0.13U W=1U
Mt2tx_Mn_f7 PAD$5 t2tx/GN VSS VSS nfet L=0.13U W=1U
Mt2tx_Mn_f8 PAD$5 t2tx/GN VSS VSS nfet L=0.13U W=1U
Mt2tx_Mn_f9 PAD$5 t2tx/GN VSS VSS nfet L=0.13U W=1U
Mt2tx_Mn_f10 PAD$5 t2tx/GN VSS VSS nfet L=0.13U W=1U
Mt2tx_Mn_f11 PAD$5 t2tx/GN VSS VSS nfet L=0.13U W=1U
Mt2tx_Mn_f12 PAD$5 t2tx/GN VSS VSS nfet L=0.13U W=1U
Mt2tx_Mn_f13 PAD$5 t2tx/GN VSS VSS nfet L=0.13U W=1U
Mt2tx_Mpu_f0 t2tx/PUX PUN VDDIO VDDIO pfet L=0.13U W=2U
Xt2tx_Rpu t2tx/PUX PAD$5 VSS rppd r=12472.0 L=24U W=0.5U
Mt2tx_Mpd_f0 t2tx/PDX PD VSS VSS nfet L=0.13U W=1U
Xt2tx_Rpd PAD$5 t2tx/PDX VSS rppd r=12472.0 L=24U W=0.5U
Dt3esd_Dp1 PAD$7 VDDIO dpantenna A=100P P=40U
Dt3esd_Dn1 VSS PAD$7 dantenna A=100P P=40U
Mt3esd_Mclamp_f0 VDDIO VSS VSS VSS nfet L=0.35U W=2U
Mt3esd_Mclamp_f1 VDDIO VSS VSS VSS nfet L=0.35U W=2U
Mt3esd_Mclamp_f2 VDDIO VSS VSS VSS nfet L=0.35U W=2U
Mt3esd_Mclamp_f3 VDDIO VSS VSS VSS nfet L=0.35U W=2U
Mt3esd_Mclamp_f4 VDDIO VSS VSS VSS nfet L=0.35U W=2U
Mt3esd_Mclamp_f5 VDDIO VSS VSS VSS nfet L=0.35U W=2U
Mt3esd_Mclamp_f6 VDDIO VSS VSS VSS nfet L=0.35U W=2U
Mt3esd_Mclamp_f7 VDDIO VSS VSS VSS nfet L=0.35U W=2U
Mt3esd_Mclamp_f8 VDDIO VSS VSS VSS nfet L=0.35U W=2U
Mt3esd_Mclamp_f9 VDDIO VSS VSS VSS nfet L=0.35U W=2U
Mt3esd_Mclamp_f10 VDDIO VSS VSS VSS nfet L=0.35U W=2U
Mt3esd_Mclamp_f11 VDDIO VSS VSS VSS nfet L=0.35U W=2U
Mt3esd_Mclamp_f12 VDDIO VSS VSS VSS nfet L=0.35U W=2U
Mt3esd_Mclamp_f13 VDDIO VSS VSS VSS nfet L=0.35U W=2U
Mt3esd_Mclamp_f14 VDDIO VSS VSS VSS nfet L=0.35U W=2U
Mt3esd_Mclamp_f15 VDDIO VSS VSS VSS nfet L=0.35U W=2U
Mt3esd_Mclamp_f16 VDDIO VSS VSS VSS nfet L=0.35U W=2U
Mt3esd_Mclamp_f17 VDDIO VSS VSS VSS nfet L=0.35U W=2U
Mt3esd_Mclamp_f18 VDDIO VSS VSS VSS nfet L=0.35U W=2U
Mt3esd_Mclamp_f19 VDDIO VSS VSS VSS nfet L=0.35U W=2U
Xt3esd_Resd PAD$7 PADI_T3 VSS rppd r=294.2 L=2U W=2U
Dt3esd_Dp2 PADI_T3 VDDIO dpantenna A=4P P=8U
Mt3esd_Mn2_f0 PADI_T3 VSS VSS VSS nfet L=0.13U W=1U
Mt3tx_Mi1p_f0 t3tx/OEB OE VDDIO VDDIO pfet L=0.13U W=2U
Mt3tx_Mi1n_f0 t3tx/OEB OE VSS VSS nfet L=0.13U W=1U
Mt3tx_Mnd1p_f0 t3tx/GP DIN$3 VDDIO VDDIO pfet L=0.13U W=2U
Mt3tx_Mnd1p_f1 t3tx/GP DIN$3 VDDIO VDDIO pfet L=0.13U W=2U
Mt3tx_Mnd2p_f0 t3tx/GP OE VDDIO VDDIO pfet L=0.13U W=2U
Mt3tx_Mnd2p_f1 t3tx/GP OE VDDIO VDDIO pfet L=0.13U W=2U
Mt3tx_Mnd1n_f0 t3tx/GP DIN$3 t3tx/NA VSS nfet L=0.13U W=2U
Mt3tx_Mnd1n_f1 t3tx/GP DIN$3 t3tx/NA VSS nfet L=0.13U W=2U
Mt3tx_Mnd2n_f0 t3tx/NA OE VSS VSS nfet L=0.13U W=2U
Mt3tx_Mnd2n_f1 t3tx/NA OE VSS VSS nfet L=0.13U W=2U
Mt3tx_Mnr1p_f0 t3tx/NB DIN$3 VDDIO VDDIO pfet L=0.13U W=2U
Mt3tx_Mnr1p_f1 t3tx/NB DIN$3 VDDIO VDDIO pfet L=0.13U W=2U
Mt3tx_Mnr2p_f0 t3tx/GN t3tx/OEB t3tx/NB VDDIO pfet L=0.13U W=2U
Mt3tx_Mnr2p_f1 t3tx/GN t3tx/OEB t3tx/NB VDDIO pfet L=0.13U W=2U
Mt3tx_Mnr1n_f0 t3tx/GN DIN$3 VSS VSS nfet L=0.13U W=1U
Mt3tx_Mnr1n_f1 t3tx/GN DIN$3 VSS VSS nfet L=0.13U W=1U
Mt3tx_Mnr2n_f0 t3tx/GN t3tx/OEB VSS VSS nfet L=0.13U W=1U
Mt3tx_Mnr2n_f1 t3tx/GN t3tx/OEB VSS VSS nfet L=0.13U W=1U
Mt3tx_Mp_f0 PAD$7 t3tx/GP VDDIO VDDIO pfet L=0.13U W=1U
Mt3tx_Mp_f1 PAD$7 t3tx/GP VDDIO VDDIO pfet L=0.13U W=1U
Mt3tx_Mp_f2 PAD$7 t3tx/GP VDDIO VDDIO pfet L=0.13U W=1U
Mt3tx_Mp_f3 PAD$7 t3tx/GP VDDIO VDDIO pfet L=0.13U W=1U
Mt3tx_Mp_f4 PAD$7 t3tx/GP VDDIO VDDIO pfet L=0.13U W=1U
Mt3tx_Mp_f5 PAD$7 t3tx/GP VDDIO VDDIO pfet L=0.13U W=1U
Mt3tx_Mp_f6 PAD$7 t3tx/GP VDDIO VDDIO pfet L=0.13U W=1U
Mt3tx_Mp_f7 PAD$7 t3tx/GP VDDIO VDDIO pfet L=0.13U W=1U
Mt3tx_Mp_f8 PAD$7 t3tx/GP VDDIO VDDIO pfet L=0.13U W=1U
Mt3tx_Mp_f9 PAD$7 t3tx/GP VDDIO VDDIO pfet L=0.13U W=1U
Mt3tx_Mp_f10 PAD$7 t3tx/GP VDDIO VDDIO pfet L=0.13U W=1U
Mt3tx_Mp_f11 PAD$7 t3tx/GP VDDIO VDDIO pfet L=0.13U W=1U
Mt3tx_Mp_f12 PAD$7 t3tx/GP VDDIO VDDIO pfet L=0.13U W=1U
Mt3tx_Mp_f13 PAD$7 t3tx/GP VDDIO VDDIO pfet L=0.13U W=1U
Mt3tx_Mp_f14 PAD$7 t3tx/GP VDDIO VDDIO pfet L=0.13U W=1U
Mt3tx_Mp_f15 PAD$7 t3tx/GP VDDIO VDDIO pfet L=0.13U W=1U
Mt3tx_Mp_f16 PAD$7 t3tx/GP VDDIO VDDIO pfet L=0.13U W=1U
Mt3tx_Mp_f17 PAD$7 t3tx/GP VDDIO VDDIO pfet L=0.13U W=1U
Mt3tx_Mp_f18 PAD$7 t3tx/GP VDDIO VDDIO pfet L=0.13U W=1U
Mt3tx_Mp_f19 PAD$7 t3tx/GP VDDIO VDDIO pfet L=0.13U W=1U
Mt3tx_Mp_f20 PAD$7 t3tx/GP VDDIO VDDIO pfet L=0.13U W=1U
Mt3tx_Mp_f21 PAD$7 t3tx/GP VDDIO VDDIO pfet L=0.13U W=1U
Mt3tx_Mp_f22 PAD$7 t3tx/GP VDDIO VDDIO pfet L=0.13U W=1U
Mt3tx_Mp_f23 PAD$7 t3tx/GP VDDIO VDDIO pfet L=0.13U W=1U
Mt3tx_Mp_f24 PAD$7 t3tx/GP VDDIO VDDIO pfet L=0.13U W=1U
Mt3tx_Mp_f25 PAD$7 t3tx/GP VDDIO VDDIO pfet L=0.13U W=1U
Mt3tx_Mp_f26 PAD$7 t3tx/GP VDDIO VDDIO pfet L=0.13U W=1U
Mt3tx_Mp_f27 PAD$7 t3tx/GP VDDIO VDDIO pfet L=0.13U W=1U
Mt3tx_Mn_f0 PAD$7 t3tx/GN VSS VSS nfet L=0.13U W=1U
Mt3tx_Mn_f1 PAD$7 t3tx/GN VSS VSS nfet L=0.13U W=1U
Mt3tx_Mn_f2 PAD$7 t3tx/GN VSS VSS nfet L=0.13U W=1U
Mt3tx_Mn_f3 PAD$7 t3tx/GN VSS VSS nfet L=0.13U W=1U
Mt3tx_Mn_f4 PAD$7 t3tx/GN VSS VSS nfet L=0.13U W=1U
Mt3tx_Mn_f5 PAD$7 t3tx/GN VSS VSS nfet L=0.13U W=1U
Mt3tx_Mn_f6 PAD$7 t3tx/GN VSS VSS nfet L=0.13U W=1U
Mt3tx_Mn_f7 PAD$7 t3tx/GN VSS VSS nfet L=0.13U W=1U
Mt3tx_Mn_f8 PAD$7 t3tx/GN VSS VSS nfet L=0.13U W=1U
Mt3tx_Mn_f9 PAD$7 t3tx/GN VSS VSS nfet L=0.13U W=1U
Mt3tx_Mn_f10 PAD$7 t3tx/GN VSS VSS nfet L=0.13U W=1U
Mt3tx_Mn_f11 PAD$7 t3tx/GN VSS VSS nfet L=0.13U W=1U
Mt3tx_Mn_f12 PAD$7 t3tx/GN VSS VSS nfet L=0.13U W=1U
Mt3tx_Mn_f13 PAD$7 t3tx/GN VSS VSS nfet L=0.13U W=1U
Mt3tx_Mpu_f0 t3tx/PUX PUN VDDIO VDDIO pfet L=0.13U W=2U
Xt3tx_Rpu t3tx/PUX PAD$7 VSS rppd r=12472.0 L=24U W=0.5U
Mt3tx_Mpd_f0 t3tx/PDX PD VSS VSS nfet L=0.13U W=1U
Xt3tx_Rpd PAD$7 t3tx/PDX VSS rppd r=12472.0 L=24U W=0.5U
Dt4esd_Dp1 PAD$9 VDDIO dpantenna A=100P P=40U
Dt4esd_Dn1 VSS PAD$9 dantenna A=100P P=40U
Mt4esd_Mclamp_f0 VDDIO VSS VSS VSS nfet L=0.35U W=2U
Mt4esd_Mclamp_f1 VDDIO VSS VSS VSS nfet L=0.35U W=2U
Mt4esd_Mclamp_f2 VDDIO VSS VSS VSS nfet L=0.35U W=2U
Mt4esd_Mclamp_f3 VDDIO VSS VSS VSS nfet L=0.35U W=2U
Mt4esd_Mclamp_f4 VDDIO VSS VSS VSS nfet L=0.35U W=2U
Mt4esd_Mclamp_f5 VDDIO VSS VSS VSS nfet L=0.35U W=2U
Mt4esd_Mclamp_f6 VDDIO VSS VSS VSS nfet L=0.35U W=2U
Mt4esd_Mclamp_f7 VDDIO VSS VSS VSS nfet L=0.35U W=2U
Mt4esd_Mclamp_f8 VDDIO VSS VSS VSS nfet L=0.35U W=2U
Mt4esd_Mclamp_f9 VDDIO VSS VSS VSS nfet L=0.35U W=2U
Mt4esd_Mclamp_f10 VDDIO VSS VSS VSS nfet L=0.35U W=2U
Mt4esd_Mclamp_f11 VDDIO VSS VSS VSS nfet L=0.35U W=2U
Mt4esd_Mclamp_f12 VDDIO VSS VSS VSS nfet L=0.35U W=2U
Mt4esd_Mclamp_f13 VDDIO VSS VSS VSS nfet L=0.35U W=2U
Mt4esd_Mclamp_f14 VDDIO VSS VSS VSS nfet L=0.35U W=2U
Mt4esd_Mclamp_f15 VDDIO VSS VSS VSS nfet L=0.35U W=2U
Mt4esd_Mclamp_f16 VDDIO VSS VSS VSS nfet L=0.35U W=2U
Mt4esd_Mclamp_f17 VDDIO VSS VSS VSS nfet L=0.35U W=2U
Mt4esd_Mclamp_f18 VDDIO VSS VSS VSS nfet L=0.35U W=2U
Mt4esd_Mclamp_f19 VDDIO VSS VSS VSS nfet L=0.35U W=2U
Xt4esd_Resd PAD$9 PADI_T4 VSS rppd r=294.2 L=2U W=2U
Dt4esd_Dp2 PADI_T4 VDDIO dpantenna A=4P P=8U
Mt4esd_Mn2_f0 PADI_T4 VSS VSS VSS nfet L=0.13U W=1U
Mt4tx_Mi1p_f0 t4tx/OEB OE VDDIO VDDIO pfet L=0.13U W=2U
Mt4tx_Mi1n_f0 t4tx/OEB OE VSS VSS nfet L=0.13U W=1U
Mt4tx_Mnd1p_f0 t4tx/GP DIN$4 VDDIO VDDIO pfet L=0.13U W=2U
Mt4tx_Mnd1p_f1 t4tx/GP DIN$4 VDDIO VDDIO pfet L=0.13U W=2U
Mt4tx_Mnd2p_f0 t4tx/GP OE VDDIO VDDIO pfet L=0.13U W=2U
Mt4tx_Mnd2p_f1 t4tx/GP OE VDDIO VDDIO pfet L=0.13U W=2U
Mt4tx_Mnd1n_f0 t4tx/GP DIN$4 t4tx/NA VSS nfet L=0.13U W=2U
Mt4tx_Mnd1n_f1 t4tx/GP DIN$4 t4tx/NA VSS nfet L=0.13U W=2U
Mt4tx_Mnd2n_f0 t4tx/NA OE VSS VSS nfet L=0.13U W=2U
Mt4tx_Mnd2n_f1 t4tx/NA OE VSS VSS nfet L=0.13U W=2U
Mt4tx_Mnr1p_f0 t4tx/NB DIN$4 VDDIO VDDIO pfet L=0.13U W=2U
Mt4tx_Mnr1p_f1 t4tx/NB DIN$4 VDDIO VDDIO pfet L=0.13U W=2U
Mt4tx_Mnr2p_f0 t4tx/GN t4tx/OEB t4tx/NB VDDIO pfet L=0.13U W=2U
Mt4tx_Mnr2p_f1 t4tx/GN t4tx/OEB t4tx/NB VDDIO pfet L=0.13U W=2U
Mt4tx_Mnr1n_f0 t4tx/GN DIN$4 VSS VSS nfet L=0.13U W=1U
Mt4tx_Mnr1n_f1 t4tx/GN DIN$4 VSS VSS nfet L=0.13U W=1U
Mt4tx_Mnr2n_f0 t4tx/GN t4tx/OEB VSS VSS nfet L=0.13U W=1U
Mt4tx_Mnr2n_f1 t4tx/GN t4tx/OEB VSS VSS nfet L=0.13U W=1U
Mt4tx_Mp_f0 PAD$9 t4tx/GP VDDIO VDDIO pfet L=0.13U W=1U
Mt4tx_Mp_f1 PAD$9 t4tx/GP VDDIO VDDIO pfet L=0.13U W=1U
Mt4tx_Mp_f2 PAD$9 t4tx/GP VDDIO VDDIO pfet L=0.13U W=1U
Mt4tx_Mp_f3 PAD$9 t4tx/GP VDDIO VDDIO pfet L=0.13U W=1U
Mt4tx_Mp_f4 PAD$9 t4tx/GP VDDIO VDDIO pfet L=0.13U W=1U
Mt4tx_Mp_f5 PAD$9 t4tx/GP VDDIO VDDIO pfet L=0.13U W=1U
Mt4tx_Mp_f6 PAD$9 t4tx/GP VDDIO VDDIO pfet L=0.13U W=1U
Mt4tx_Mp_f7 PAD$9 t4tx/GP VDDIO VDDIO pfet L=0.13U W=1U
Mt4tx_Mp_f8 PAD$9 t4tx/GP VDDIO VDDIO pfet L=0.13U W=1U
Mt4tx_Mp_f9 PAD$9 t4tx/GP VDDIO VDDIO pfet L=0.13U W=1U
Mt4tx_Mp_f10 PAD$9 t4tx/GP VDDIO VDDIO pfet L=0.13U W=1U
Mt4tx_Mp_f11 PAD$9 t4tx/GP VDDIO VDDIO pfet L=0.13U W=1U
Mt4tx_Mp_f12 PAD$9 t4tx/GP VDDIO VDDIO pfet L=0.13U W=1U
Mt4tx_Mp_f13 PAD$9 t4tx/GP VDDIO VDDIO pfet L=0.13U W=1U
Mt4tx_Mp_f14 PAD$9 t4tx/GP VDDIO VDDIO pfet L=0.13U W=1U
Mt4tx_Mp_f15 PAD$9 t4tx/GP VDDIO VDDIO pfet L=0.13U W=1U
Mt4tx_Mp_f16 PAD$9 t4tx/GP VDDIO VDDIO pfet L=0.13U W=1U
Mt4tx_Mp_f17 PAD$9 t4tx/GP VDDIO VDDIO pfet L=0.13U W=1U
Mt4tx_Mp_f18 PAD$9 t4tx/GP VDDIO VDDIO pfet L=0.13U W=1U
Mt4tx_Mp_f19 PAD$9 t4tx/GP VDDIO VDDIO pfet L=0.13U W=1U
Mt4tx_Mp_f20 PAD$9 t4tx/GP VDDIO VDDIO pfet L=0.13U W=1U
Mt4tx_Mp_f21 PAD$9 t4tx/GP VDDIO VDDIO pfet L=0.13U W=1U
Mt4tx_Mp_f22 PAD$9 t4tx/GP VDDIO VDDIO pfet L=0.13U W=1U
Mt4tx_Mp_f23 PAD$9 t4tx/GP VDDIO VDDIO pfet L=0.13U W=1U
Mt4tx_Mp_f24 PAD$9 t4tx/GP VDDIO VDDIO pfet L=0.13U W=1U
Mt4tx_Mp_f25 PAD$9 t4tx/GP VDDIO VDDIO pfet L=0.13U W=1U
Mt4tx_Mp_f26 PAD$9 t4tx/GP VDDIO VDDIO pfet L=0.13U W=1U
Mt4tx_Mp_f27 PAD$9 t4tx/GP VDDIO VDDIO pfet L=0.13U W=1U
Mt4tx_Mn_f0 PAD$9 t4tx/GN VSS VSS nfet L=0.13U W=1U
Mt4tx_Mn_f1 PAD$9 t4tx/GN VSS VSS nfet L=0.13U W=1U
Mt4tx_Mn_f2 PAD$9 t4tx/GN VSS VSS nfet L=0.13U W=1U
Mt4tx_Mn_f3 PAD$9 t4tx/GN VSS VSS nfet L=0.13U W=1U
Mt4tx_Mn_f4 PAD$9 t4tx/GN VSS VSS nfet L=0.13U W=1U
Mt4tx_Mn_f5 PAD$9 t4tx/GN VSS VSS nfet L=0.13U W=1U
Mt4tx_Mn_f6 PAD$9 t4tx/GN VSS VSS nfet L=0.13U W=1U
Mt4tx_Mn_f7 PAD$9 t4tx/GN VSS VSS nfet L=0.13U W=1U
Mt4tx_Mn_f8 PAD$9 t4tx/GN VSS VSS nfet L=0.13U W=1U
Mt4tx_Mn_f9 PAD$9 t4tx/GN VSS VSS nfet L=0.13U W=1U
Mt4tx_Mn_f10 PAD$9 t4tx/GN VSS VSS nfet L=0.13U W=1U
Mt4tx_Mn_f11 PAD$9 t4tx/GN VSS VSS nfet L=0.13U W=1U
Mt4tx_Mn_f12 PAD$9 t4tx/GN VSS VSS nfet L=0.13U W=1U
Mt4tx_Mn_f13 PAD$9 t4tx/GN VSS VSS nfet L=0.13U W=1U
Mt4tx_Mpu_f0 t4tx/PUX PUN VDDIO VDDIO pfet L=0.13U W=2U
Xt4tx_Rpu t4tx/PUX PAD$9 VSS rppd r=12472.0 L=24U W=0.5U
Mt4tx_Mpd_f0 t4tx/PDX PD VSS VSS nfet L=0.13U W=1U
Xt4tx_Rpd PAD$9 t4tx/PDX VSS rppd r=12472.0 L=24U W=0.5U
Dt5esd_Dp1 PAD$11 VDDIO dpantenna A=100P P=40U
Dt5esd_Dn1 VSS PAD$11 dantenna A=100P P=40U
Mt5esd_Mclamp_f0 VDDIO VSS VSS VSS nfet L=0.35U W=2U
Mt5esd_Mclamp_f1 VDDIO VSS VSS VSS nfet L=0.35U W=2U
Mt5esd_Mclamp_f2 VDDIO VSS VSS VSS nfet L=0.35U W=2U
Mt5esd_Mclamp_f3 VDDIO VSS VSS VSS nfet L=0.35U W=2U
Mt5esd_Mclamp_f4 VDDIO VSS VSS VSS nfet L=0.35U W=2U
Mt5esd_Mclamp_f5 VDDIO VSS VSS VSS nfet L=0.35U W=2U
Mt5esd_Mclamp_f6 VDDIO VSS VSS VSS nfet L=0.35U W=2U
Mt5esd_Mclamp_f7 VDDIO VSS VSS VSS nfet L=0.35U W=2U
Mt5esd_Mclamp_f8 VDDIO VSS VSS VSS nfet L=0.35U W=2U
Mt5esd_Mclamp_f9 VDDIO VSS VSS VSS nfet L=0.35U W=2U
Mt5esd_Mclamp_f10 VDDIO VSS VSS VSS nfet L=0.35U W=2U
Mt5esd_Mclamp_f11 VDDIO VSS VSS VSS nfet L=0.35U W=2U
Mt5esd_Mclamp_f12 VDDIO VSS VSS VSS nfet L=0.35U W=2U
Mt5esd_Mclamp_f13 VDDIO VSS VSS VSS nfet L=0.35U W=2U
Mt5esd_Mclamp_f14 VDDIO VSS VSS VSS nfet L=0.35U W=2U
Mt5esd_Mclamp_f15 VDDIO VSS VSS VSS nfet L=0.35U W=2U
Mt5esd_Mclamp_f16 VDDIO VSS VSS VSS nfet L=0.35U W=2U
Mt5esd_Mclamp_f17 VDDIO VSS VSS VSS nfet L=0.35U W=2U
Mt5esd_Mclamp_f18 VDDIO VSS VSS VSS nfet L=0.35U W=2U
Mt5esd_Mclamp_f19 VDDIO VSS VSS VSS nfet L=0.35U W=2U
Xt5esd_Resd PAD$11 PADI_T5 VSS rppd r=294.2 L=2U W=2U
Dt5esd_Dp2 PADI_T5 VDDIO dpantenna A=4P P=8U
Mt5esd_Mn2_f0 PADI_T5 VSS VSS VSS nfet L=0.13U W=1U
Mt5tx_Mi1p_f0 t5tx/OEB OE VDDIO VDDIO pfet L=0.13U W=2U
Mt5tx_Mi1n_f0 t5tx/OEB OE VSS VSS nfet L=0.13U W=1U
Mt5tx_Mnd1p_f0 t5tx/GP DIN$5 VDDIO VDDIO pfet L=0.13U W=2U
Mt5tx_Mnd1p_f1 t5tx/GP DIN$5 VDDIO VDDIO pfet L=0.13U W=2U
Mt5tx_Mnd2p_f0 t5tx/GP OE VDDIO VDDIO pfet L=0.13U W=2U
Mt5tx_Mnd2p_f1 t5tx/GP OE VDDIO VDDIO pfet L=0.13U W=2U
Mt5tx_Mnd1n_f0 t5tx/GP DIN$5 t5tx/NA VSS nfet L=0.13U W=2U
Mt5tx_Mnd1n_f1 t5tx/GP DIN$5 t5tx/NA VSS nfet L=0.13U W=2U
Mt5tx_Mnd2n_f0 t5tx/NA OE VSS VSS nfet L=0.13U W=2U
Mt5tx_Mnd2n_f1 t5tx/NA OE VSS VSS nfet L=0.13U W=2U
Mt5tx_Mnr1p_f0 t5tx/NB DIN$5 VDDIO VDDIO pfet L=0.13U W=2U
Mt5tx_Mnr1p_f1 t5tx/NB DIN$5 VDDIO VDDIO pfet L=0.13U W=2U
Mt5tx_Mnr2p_f0 t5tx/GN t5tx/OEB t5tx/NB VDDIO pfet L=0.13U W=2U
Mt5tx_Mnr2p_f1 t5tx/GN t5tx/OEB t5tx/NB VDDIO pfet L=0.13U W=2U
Mt5tx_Mnr1n_f0 t5tx/GN DIN$5 VSS VSS nfet L=0.13U W=1U
Mt5tx_Mnr1n_f1 t5tx/GN DIN$5 VSS VSS nfet L=0.13U W=1U
Mt5tx_Mnr2n_f0 t5tx/GN t5tx/OEB VSS VSS nfet L=0.13U W=1U
Mt5tx_Mnr2n_f1 t5tx/GN t5tx/OEB VSS VSS nfet L=0.13U W=1U
Mt5tx_Mp_f0 PAD$11 t5tx/GP VDDIO VDDIO pfet L=0.13U W=1U
Mt5tx_Mp_f1 PAD$11 t5tx/GP VDDIO VDDIO pfet L=0.13U W=1U
Mt5tx_Mp_f2 PAD$11 t5tx/GP VDDIO VDDIO pfet L=0.13U W=1U
Mt5tx_Mp_f3 PAD$11 t5tx/GP VDDIO VDDIO pfet L=0.13U W=1U
Mt5tx_Mp_f4 PAD$11 t5tx/GP VDDIO VDDIO pfet L=0.13U W=1U
Mt5tx_Mp_f5 PAD$11 t5tx/GP VDDIO VDDIO pfet L=0.13U W=1U
Mt5tx_Mp_f6 PAD$11 t5tx/GP VDDIO VDDIO pfet L=0.13U W=1U
Mt5tx_Mp_f7 PAD$11 t5tx/GP VDDIO VDDIO pfet L=0.13U W=1U
Mt5tx_Mp_f8 PAD$11 t5tx/GP VDDIO VDDIO pfet L=0.13U W=1U
Mt5tx_Mp_f9 PAD$11 t5tx/GP VDDIO VDDIO pfet L=0.13U W=1U
Mt5tx_Mp_f10 PAD$11 t5tx/GP VDDIO VDDIO pfet L=0.13U W=1U
Mt5tx_Mp_f11 PAD$11 t5tx/GP VDDIO VDDIO pfet L=0.13U W=1U
Mt5tx_Mp_f12 PAD$11 t5tx/GP VDDIO VDDIO pfet L=0.13U W=1U
Mt5tx_Mp_f13 PAD$11 t5tx/GP VDDIO VDDIO pfet L=0.13U W=1U
Mt5tx_Mp_f14 PAD$11 t5tx/GP VDDIO VDDIO pfet L=0.13U W=1U
Mt5tx_Mp_f15 PAD$11 t5tx/GP VDDIO VDDIO pfet L=0.13U W=1U
Mt5tx_Mp_f16 PAD$11 t5tx/GP VDDIO VDDIO pfet L=0.13U W=1U
Mt5tx_Mp_f17 PAD$11 t5tx/GP VDDIO VDDIO pfet L=0.13U W=1U
Mt5tx_Mp_f18 PAD$11 t5tx/GP VDDIO VDDIO pfet L=0.13U W=1U
Mt5tx_Mp_f19 PAD$11 t5tx/GP VDDIO VDDIO pfet L=0.13U W=1U
Mt5tx_Mp_f20 PAD$11 t5tx/GP VDDIO VDDIO pfet L=0.13U W=1U
Mt5tx_Mp_f21 PAD$11 t5tx/GP VDDIO VDDIO pfet L=0.13U W=1U
Mt5tx_Mp_f22 PAD$11 t5tx/GP VDDIO VDDIO pfet L=0.13U W=1U
Mt5tx_Mp_f23 PAD$11 t5tx/GP VDDIO VDDIO pfet L=0.13U W=1U
Mt5tx_Mp_f24 PAD$11 t5tx/GP VDDIO VDDIO pfet L=0.13U W=1U
Mt5tx_Mp_f25 PAD$11 t5tx/GP VDDIO VDDIO pfet L=0.13U W=1U
Mt5tx_Mp_f26 PAD$11 t5tx/GP VDDIO VDDIO pfet L=0.13U W=1U
Mt5tx_Mp_f27 PAD$11 t5tx/GP VDDIO VDDIO pfet L=0.13U W=1U
Mt5tx_Mn_f0 PAD$11 t5tx/GN VSS VSS nfet L=0.13U W=1U
Mt5tx_Mn_f1 PAD$11 t5tx/GN VSS VSS nfet L=0.13U W=1U
Mt5tx_Mn_f2 PAD$11 t5tx/GN VSS VSS nfet L=0.13U W=1U
Mt5tx_Mn_f3 PAD$11 t5tx/GN VSS VSS nfet L=0.13U W=1U
Mt5tx_Mn_f4 PAD$11 t5tx/GN VSS VSS nfet L=0.13U W=1U
Mt5tx_Mn_f5 PAD$11 t5tx/GN VSS VSS nfet L=0.13U W=1U
Mt5tx_Mn_f6 PAD$11 t5tx/GN VSS VSS nfet L=0.13U W=1U
Mt5tx_Mn_f7 PAD$11 t5tx/GN VSS VSS nfet L=0.13U W=1U
Mt5tx_Mn_f8 PAD$11 t5tx/GN VSS VSS nfet L=0.13U W=1U
Mt5tx_Mn_f9 PAD$11 t5tx/GN VSS VSS nfet L=0.13U W=1U
Mt5tx_Mn_f10 PAD$11 t5tx/GN VSS VSS nfet L=0.13U W=1U
Mt5tx_Mn_f11 PAD$11 t5tx/GN VSS VSS nfet L=0.13U W=1U
Mt5tx_Mn_f12 PAD$11 t5tx/GN VSS VSS nfet L=0.13U W=1U
Mt5tx_Mn_f13 PAD$11 t5tx/GN VSS VSS nfet L=0.13U W=1U
Mt5tx_Mpu_f0 t5tx/PUX PUN VDDIO VDDIO pfet L=0.13U W=2U
Xt5tx_Rpu t5tx/PUX PAD$11 VSS rppd r=12472.0 L=24U W=0.5U
Mt5tx_Mpd_f0 t5tx/PDX PD VSS VSS nfet L=0.13U W=1U
Xt5tx_Rpd PAD$11 t5tx/PDX VSS rppd r=12472.0 L=24U W=0.5U
Dt6esd_Dp1 PAD$13 VDDIO dpantenna A=100P P=40U
Dt6esd_Dn1 VSS PAD$13 dantenna A=100P P=40U
Mt6esd_Mclamp_f0 VDDIO VSS VSS VSS nfet L=0.35U W=2U
Mt6esd_Mclamp_f1 VDDIO VSS VSS VSS nfet L=0.35U W=2U
Mt6esd_Mclamp_f2 VDDIO VSS VSS VSS nfet L=0.35U W=2U
Mt6esd_Mclamp_f3 VDDIO VSS VSS VSS nfet L=0.35U W=2U
Mt6esd_Mclamp_f4 VDDIO VSS VSS VSS nfet L=0.35U W=2U
Mt6esd_Mclamp_f5 VDDIO VSS VSS VSS nfet L=0.35U W=2U
Mt6esd_Mclamp_f6 VDDIO VSS VSS VSS nfet L=0.35U W=2U
Mt6esd_Mclamp_f7 VDDIO VSS VSS VSS nfet L=0.35U W=2U
Mt6esd_Mclamp_f8 VDDIO VSS VSS VSS nfet L=0.35U W=2U
Mt6esd_Mclamp_f9 VDDIO VSS VSS VSS nfet L=0.35U W=2U
Mt6esd_Mclamp_f10 VDDIO VSS VSS VSS nfet L=0.35U W=2U
Mt6esd_Mclamp_f11 VDDIO VSS VSS VSS nfet L=0.35U W=2U
Mt6esd_Mclamp_f12 VDDIO VSS VSS VSS nfet L=0.35U W=2U
Mt6esd_Mclamp_f13 VDDIO VSS VSS VSS nfet L=0.35U W=2U
Mt6esd_Mclamp_f14 VDDIO VSS VSS VSS nfet L=0.35U W=2U
Mt6esd_Mclamp_f15 VDDIO VSS VSS VSS nfet L=0.35U W=2U
Mt6esd_Mclamp_f16 VDDIO VSS VSS VSS nfet L=0.35U W=2U
Mt6esd_Mclamp_f17 VDDIO VSS VSS VSS nfet L=0.35U W=2U
Mt6esd_Mclamp_f18 VDDIO VSS VSS VSS nfet L=0.35U W=2U
Mt6esd_Mclamp_f19 VDDIO VSS VSS VSS nfet L=0.35U W=2U
Xt6esd_Resd PAD$13 PADI_T6 VSS rppd r=294.2 L=2U W=2U
Dt6esd_Dp2 PADI_T6 VDDIO dpantenna A=4P P=8U
Mt6esd_Mn2_f0 PADI_T6 VSS VSS VSS nfet L=0.13U W=1U
Mt6tx_Mi1p_f0 t6tx/OEB OE VDDIO VDDIO pfet L=0.13U W=2U
Mt6tx_Mi1n_f0 t6tx/OEB OE VSS VSS nfet L=0.13U W=1U
Mt6tx_Mnd1p_f0 t6tx/GP DIN$6 VDDIO VDDIO pfet L=0.13U W=2U
Mt6tx_Mnd1p_f1 t6tx/GP DIN$6 VDDIO VDDIO pfet L=0.13U W=2U
Mt6tx_Mnd2p_f0 t6tx/GP OE VDDIO VDDIO pfet L=0.13U W=2U
Mt6tx_Mnd2p_f1 t6tx/GP OE VDDIO VDDIO pfet L=0.13U W=2U
Mt6tx_Mnd1n_f0 t6tx/GP DIN$6 t6tx/NA VSS nfet L=0.13U W=2U
Mt6tx_Mnd1n_f1 t6tx/GP DIN$6 t6tx/NA VSS nfet L=0.13U W=2U
Mt6tx_Mnd2n_f0 t6tx/NA OE VSS VSS nfet L=0.13U W=2U
Mt6tx_Mnd2n_f1 t6tx/NA OE VSS VSS nfet L=0.13U W=2U
Mt6tx_Mnr1p_f0 t6tx/NB DIN$6 VDDIO VDDIO pfet L=0.13U W=2U
Mt6tx_Mnr1p_f1 t6tx/NB DIN$6 VDDIO VDDIO pfet L=0.13U W=2U
Mt6tx_Mnr2p_f0 t6tx/GN t6tx/OEB t6tx/NB VDDIO pfet L=0.13U W=2U
Mt6tx_Mnr2p_f1 t6tx/GN t6tx/OEB t6tx/NB VDDIO pfet L=0.13U W=2U
Mt6tx_Mnr1n_f0 t6tx/GN DIN$6 VSS VSS nfet L=0.13U W=1U
Mt6tx_Mnr1n_f1 t6tx/GN DIN$6 VSS VSS nfet L=0.13U W=1U
Mt6tx_Mnr2n_f0 t6tx/GN t6tx/OEB VSS VSS nfet L=0.13U W=1U
Mt6tx_Mnr2n_f1 t6tx/GN t6tx/OEB VSS VSS nfet L=0.13U W=1U
Mt6tx_Mp_f0 PAD$13 t6tx/GP VDDIO VDDIO pfet L=0.13U W=1U
Mt6tx_Mp_f1 PAD$13 t6tx/GP VDDIO VDDIO pfet L=0.13U W=1U
Mt6tx_Mp_f2 PAD$13 t6tx/GP VDDIO VDDIO pfet L=0.13U W=1U
Mt6tx_Mp_f3 PAD$13 t6tx/GP VDDIO VDDIO pfet L=0.13U W=1U
Mt6tx_Mp_f4 PAD$13 t6tx/GP VDDIO VDDIO pfet L=0.13U W=1U
Mt6tx_Mp_f5 PAD$13 t6tx/GP VDDIO VDDIO pfet L=0.13U W=1U
Mt6tx_Mp_f6 PAD$13 t6tx/GP VDDIO VDDIO pfet L=0.13U W=1U
Mt6tx_Mp_f7 PAD$13 t6tx/GP VDDIO VDDIO pfet L=0.13U W=1U
Mt6tx_Mp_f8 PAD$13 t6tx/GP VDDIO VDDIO pfet L=0.13U W=1U
Mt6tx_Mp_f9 PAD$13 t6tx/GP VDDIO VDDIO pfet L=0.13U W=1U
Mt6tx_Mp_f10 PAD$13 t6tx/GP VDDIO VDDIO pfet L=0.13U W=1U
Mt6tx_Mp_f11 PAD$13 t6tx/GP VDDIO VDDIO pfet L=0.13U W=1U
Mt6tx_Mp_f12 PAD$13 t6tx/GP VDDIO VDDIO pfet L=0.13U W=1U
Mt6tx_Mp_f13 PAD$13 t6tx/GP VDDIO VDDIO pfet L=0.13U W=1U
Mt6tx_Mp_f14 PAD$13 t6tx/GP VDDIO VDDIO pfet L=0.13U W=1U
Mt6tx_Mp_f15 PAD$13 t6tx/GP VDDIO VDDIO pfet L=0.13U W=1U
Mt6tx_Mp_f16 PAD$13 t6tx/GP VDDIO VDDIO pfet L=0.13U W=1U
Mt6tx_Mp_f17 PAD$13 t6tx/GP VDDIO VDDIO pfet L=0.13U W=1U
Mt6tx_Mp_f18 PAD$13 t6tx/GP VDDIO VDDIO pfet L=0.13U W=1U
Mt6tx_Mp_f19 PAD$13 t6tx/GP VDDIO VDDIO pfet L=0.13U W=1U
Mt6tx_Mp_f20 PAD$13 t6tx/GP VDDIO VDDIO pfet L=0.13U W=1U
Mt6tx_Mp_f21 PAD$13 t6tx/GP VDDIO VDDIO pfet L=0.13U W=1U
Mt6tx_Mp_f22 PAD$13 t6tx/GP VDDIO VDDIO pfet L=0.13U W=1U
Mt6tx_Mp_f23 PAD$13 t6tx/GP VDDIO VDDIO pfet L=0.13U W=1U
Mt6tx_Mp_f24 PAD$13 t6tx/GP VDDIO VDDIO pfet L=0.13U W=1U
Mt6tx_Mp_f25 PAD$13 t6tx/GP VDDIO VDDIO pfet L=0.13U W=1U
Mt6tx_Mp_f26 PAD$13 t6tx/GP VDDIO VDDIO pfet L=0.13U W=1U
Mt6tx_Mp_f27 PAD$13 t6tx/GP VDDIO VDDIO pfet L=0.13U W=1U
Mt6tx_Mn_f0 PAD$13 t6tx/GN VSS VSS nfet L=0.13U W=1U
Mt6tx_Mn_f1 PAD$13 t6tx/GN VSS VSS nfet L=0.13U W=1U
Mt6tx_Mn_f2 PAD$13 t6tx/GN VSS VSS nfet L=0.13U W=1U
Mt6tx_Mn_f3 PAD$13 t6tx/GN VSS VSS nfet L=0.13U W=1U
Mt6tx_Mn_f4 PAD$13 t6tx/GN VSS VSS nfet L=0.13U W=1U
Mt6tx_Mn_f5 PAD$13 t6tx/GN VSS VSS nfet L=0.13U W=1U
Mt6tx_Mn_f6 PAD$13 t6tx/GN VSS VSS nfet L=0.13U W=1U
Mt6tx_Mn_f7 PAD$13 t6tx/GN VSS VSS nfet L=0.13U W=1U
Mt6tx_Mn_f8 PAD$13 t6tx/GN VSS VSS nfet L=0.13U W=1U
Mt6tx_Mn_f9 PAD$13 t6tx/GN VSS VSS nfet L=0.13U W=1U
Mt6tx_Mn_f10 PAD$13 t6tx/GN VSS VSS nfet L=0.13U W=1U
Mt6tx_Mn_f11 PAD$13 t6tx/GN VSS VSS nfet L=0.13U W=1U
Mt6tx_Mn_f12 PAD$13 t6tx/GN VSS VSS nfet L=0.13U W=1U
Mt6tx_Mn_f13 PAD$13 t6tx/GN VSS VSS nfet L=0.13U W=1U
Mt6tx_Mpu_f0 t6tx/PUX PUN VDDIO VDDIO pfet L=0.13U W=2U
Xt6tx_Rpu t6tx/PUX PAD$13 VSS rppd r=12472.0 L=24U W=0.5U
Mt6tx_Mpd_f0 t6tx/PDX PD VSS VSS nfet L=0.13U W=1U
Xt6tx_Rpd PAD$13 t6tx/PDX VSS rppd r=12472.0 L=24U W=0.5U
Dt7esd_Dp1 PAD$15 VDDIO dpantenna A=100P P=40U
Dt7esd_Dn1 VSS PAD$15 dantenna A=100P P=40U
Mt7esd_Mclamp_f0 VDDIO VSS VSS VSS nfet L=0.35U W=2U
Mt7esd_Mclamp_f1 VDDIO VSS VSS VSS nfet L=0.35U W=2U
Mt7esd_Mclamp_f2 VDDIO VSS VSS VSS nfet L=0.35U W=2U
Mt7esd_Mclamp_f3 VDDIO VSS VSS VSS nfet L=0.35U W=2U
Mt7esd_Mclamp_f4 VDDIO VSS VSS VSS nfet L=0.35U W=2U
Mt7esd_Mclamp_f5 VDDIO VSS VSS VSS nfet L=0.35U W=2U
Mt7esd_Mclamp_f6 VDDIO VSS VSS VSS nfet L=0.35U W=2U
Mt7esd_Mclamp_f7 VDDIO VSS VSS VSS nfet L=0.35U W=2U
Mt7esd_Mclamp_f8 VDDIO VSS VSS VSS nfet L=0.35U W=2U
Mt7esd_Mclamp_f9 VDDIO VSS VSS VSS nfet L=0.35U W=2U
Mt7esd_Mclamp_f10 VDDIO VSS VSS VSS nfet L=0.35U W=2U
Mt7esd_Mclamp_f11 VDDIO VSS VSS VSS nfet L=0.35U W=2U
Mt7esd_Mclamp_f12 VDDIO VSS VSS VSS nfet L=0.35U W=2U
Mt7esd_Mclamp_f13 VDDIO VSS VSS VSS nfet L=0.35U W=2U
Mt7esd_Mclamp_f14 VDDIO VSS VSS VSS nfet L=0.35U W=2U
Mt7esd_Mclamp_f15 VDDIO VSS VSS VSS nfet L=0.35U W=2U
Mt7esd_Mclamp_f16 VDDIO VSS VSS VSS nfet L=0.35U W=2U
Mt7esd_Mclamp_f17 VDDIO VSS VSS VSS nfet L=0.35U W=2U
Mt7esd_Mclamp_f18 VDDIO VSS VSS VSS nfet L=0.35U W=2U
Mt7esd_Mclamp_f19 VDDIO VSS VSS VSS nfet L=0.35U W=2U
Xt7esd_Resd PAD$15 PADI_T7 VSS rppd r=294.2 L=2U W=2U
Dt7esd_Dp2 PADI_T7 VDDIO dpantenna A=4P P=8U
Mt7esd_Mn2_f0 PADI_T7 VSS VSS VSS nfet L=0.13U W=1U
Mt7tx_Mi1p_f0 t7tx/OEB OE VDDIO VDDIO pfet L=0.13U W=2U
Mt7tx_Mi1n_f0 t7tx/OEB OE VSS VSS nfet L=0.13U W=1U
Mt7tx_Mnd1p_f0 t7tx/GP DIN$7 VDDIO VDDIO pfet L=0.13U W=2U
Mt7tx_Mnd1p_f1 t7tx/GP DIN$7 VDDIO VDDIO pfet L=0.13U W=2U
Mt7tx_Mnd2p_f0 t7tx/GP OE VDDIO VDDIO pfet L=0.13U W=2U
Mt7tx_Mnd2p_f1 t7tx/GP OE VDDIO VDDIO pfet L=0.13U W=2U
Mt7tx_Mnd1n_f0 t7tx/GP DIN$7 t7tx/NA VSS nfet L=0.13U W=2U
Mt7tx_Mnd1n_f1 t7tx/GP DIN$7 t7tx/NA VSS nfet L=0.13U W=2U
Mt7tx_Mnd2n_f0 t7tx/NA OE VSS VSS nfet L=0.13U W=2U
Mt7tx_Mnd2n_f1 t7tx/NA OE VSS VSS nfet L=0.13U W=2U
Mt7tx_Mnr1p_f0 t7tx/NB DIN$7 VDDIO VDDIO pfet L=0.13U W=2U
Mt7tx_Mnr1p_f1 t7tx/NB DIN$7 VDDIO VDDIO pfet L=0.13U W=2U
Mt7tx_Mnr2p_f0 t7tx/GN t7tx/OEB t7tx/NB VDDIO pfet L=0.13U W=2U
Mt7tx_Mnr2p_f1 t7tx/GN t7tx/OEB t7tx/NB VDDIO pfet L=0.13U W=2U
Mt7tx_Mnr1n_f0 t7tx/GN DIN$7 VSS VSS nfet L=0.13U W=1U
Mt7tx_Mnr1n_f1 t7tx/GN DIN$7 VSS VSS nfet L=0.13U W=1U
Mt7tx_Mnr2n_f0 t7tx/GN t7tx/OEB VSS VSS nfet L=0.13U W=1U
Mt7tx_Mnr2n_f1 t7tx/GN t7tx/OEB VSS VSS nfet L=0.13U W=1U
Mt7tx_Mp_f0 PAD$15 t7tx/GP VDDIO VDDIO pfet L=0.13U W=1U
Mt7tx_Mp_f1 PAD$15 t7tx/GP VDDIO VDDIO pfet L=0.13U W=1U
Mt7tx_Mp_f2 PAD$15 t7tx/GP VDDIO VDDIO pfet L=0.13U W=1U
Mt7tx_Mp_f3 PAD$15 t7tx/GP VDDIO VDDIO pfet L=0.13U W=1U
Mt7tx_Mp_f4 PAD$15 t7tx/GP VDDIO VDDIO pfet L=0.13U W=1U
Mt7tx_Mp_f5 PAD$15 t7tx/GP VDDIO VDDIO pfet L=0.13U W=1U
Mt7tx_Mp_f6 PAD$15 t7tx/GP VDDIO VDDIO pfet L=0.13U W=1U
Mt7tx_Mp_f7 PAD$15 t7tx/GP VDDIO VDDIO pfet L=0.13U W=1U
Mt7tx_Mp_f8 PAD$15 t7tx/GP VDDIO VDDIO pfet L=0.13U W=1U
Mt7tx_Mp_f9 PAD$15 t7tx/GP VDDIO VDDIO pfet L=0.13U W=1U
Mt7tx_Mp_f10 PAD$15 t7tx/GP VDDIO VDDIO pfet L=0.13U W=1U
Mt7tx_Mp_f11 PAD$15 t7tx/GP VDDIO VDDIO pfet L=0.13U W=1U
Mt7tx_Mp_f12 PAD$15 t7tx/GP VDDIO VDDIO pfet L=0.13U W=1U
Mt7tx_Mp_f13 PAD$15 t7tx/GP VDDIO VDDIO pfet L=0.13U W=1U
Mt7tx_Mp_f14 PAD$15 t7tx/GP VDDIO VDDIO pfet L=0.13U W=1U
Mt7tx_Mp_f15 PAD$15 t7tx/GP VDDIO VDDIO pfet L=0.13U W=1U
Mt7tx_Mp_f16 PAD$15 t7tx/GP VDDIO VDDIO pfet L=0.13U W=1U
Mt7tx_Mp_f17 PAD$15 t7tx/GP VDDIO VDDIO pfet L=0.13U W=1U
Mt7tx_Mp_f18 PAD$15 t7tx/GP VDDIO VDDIO pfet L=0.13U W=1U
Mt7tx_Mp_f19 PAD$15 t7tx/GP VDDIO VDDIO pfet L=0.13U W=1U
Mt7tx_Mp_f20 PAD$15 t7tx/GP VDDIO VDDIO pfet L=0.13U W=1U
Mt7tx_Mp_f21 PAD$15 t7tx/GP VDDIO VDDIO pfet L=0.13U W=1U
Mt7tx_Mp_f22 PAD$15 t7tx/GP VDDIO VDDIO pfet L=0.13U W=1U
Mt7tx_Mp_f23 PAD$15 t7tx/GP VDDIO VDDIO pfet L=0.13U W=1U
Mt7tx_Mp_f24 PAD$15 t7tx/GP VDDIO VDDIO pfet L=0.13U W=1U
Mt7tx_Mp_f25 PAD$15 t7tx/GP VDDIO VDDIO pfet L=0.13U W=1U
Mt7tx_Mp_f26 PAD$15 t7tx/GP VDDIO VDDIO pfet L=0.13U W=1U
Mt7tx_Mp_f27 PAD$15 t7tx/GP VDDIO VDDIO pfet L=0.13U W=1U
Mt7tx_Mn_f0 PAD$15 t7tx/GN VSS VSS nfet L=0.13U W=1U
Mt7tx_Mn_f1 PAD$15 t7tx/GN VSS VSS nfet L=0.13U W=1U
Mt7tx_Mn_f2 PAD$15 t7tx/GN VSS VSS nfet L=0.13U W=1U
Mt7tx_Mn_f3 PAD$15 t7tx/GN VSS VSS nfet L=0.13U W=1U
Mt7tx_Mn_f4 PAD$15 t7tx/GN VSS VSS nfet L=0.13U W=1U
Mt7tx_Mn_f5 PAD$15 t7tx/GN VSS VSS nfet L=0.13U W=1U
Mt7tx_Mn_f6 PAD$15 t7tx/GN VSS VSS nfet L=0.13U W=1U
Mt7tx_Mn_f7 PAD$15 t7tx/GN VSS VSS nfet L=0.13U W=1U
Mt7tx_Mn_f8 PAD$15 t7tx/GN VSS VSS nfet L=0.13U W=1U
Mt7tx_Mn_f9 PAD$15 t7tx/GN VSS VSS nfet L=0.13U W=1U
Mt7tx_Mn_f10 PAD$15 t7tx/GN VSS VSS nfet L=0.13U W=1U
Mt7tx_Mn_f11 PAD$15 t7tx/GN VSS VSS nfet L=0.13U W=1U
Mt7tx_Mn_f12 PAD$15 t7tx/GN VSS VSS nfet L=0.13U W=1U
Mt7tx_Mn_f13 PAD$15 t7tx/GN VSS VSS nfet L=0.13U W=1U
Mt7tx_Mpu_f0 t7tx/PUX PUN VDDIO VDDIO pfet L=0.13U W=2U
Xt7tx_Rpu t7tx/PUX PAD$15 VSS rppd r=12472.0 L=24U W=0.5U
Mt7tx_Mpd_f0 t7tx/PDX PD VSS VSS nfet L=0.13U W=1U
Xt7tx_Rpd PAD$15 t7tx/PDX VSS rppd r=12472.0 L=24U W=0.5U
Dt8esd_Dp1 PAD$17 VDDIO dpantenna A=100P P=40U
Dt8esd_Dn1 VSS PAD$17 dantenna A=100P P=40U
Mt8esd_Mclamp_f0 VDDIO VSS VSS VSS nfet L=0.35U W=2U
Mt8esd_Mclamp_f1 VDDIO VSS VSS VSS nfet L=0.35U W=2U
Mt8esd_Mclamp_f2 VDDIO VSS VSS VSS nfet L=0.35U W=2U
Mt8esd_Mclamp_f3 VDDIO VSS VSS VSS nfet L=0.35U W=2U
Mt8esd_Mclamp_f4 VDDIO VSS VSS VSS nfet L=0.35U W=2U
Mt8esd_Mclamp_f5 VDDIO VSS VSS VSS nfet L=0.35U W=2U
Mt8esd_Mclamp_f6 VDDIO VSS VSS VSS nfet L=0.35U W=2U
Mt8esd_Mclamp_f7 VDDIO VSS VSS VSS nfet L=0.35U W=2U
Mt8esd_Mclamp_f8 VDDIO VSS VSS VSS nfet L=0.35U W=2U
Mt8esd_Mclamp_f9 VDDIO VSS VSS VSS nfet L=0.35U W=2U
Mt8esd_Mclamp_f10 VDDIO VSS VSS VSS nfet L=0.35U W=2U
Mt8esd_Mclamp_f11 VDDIO VSS VSS VSS nfet L=0.35U W=2U
Mt8esd_Mclamp_f12 VDDIO VSS VSS VSS nfet L=0.35U W=2U
Mt8esd_Mclamp_f13 VDDIO VSS VSS VSS nfet L=0.35U W=2U
Mt8esd_Mclamp_f14 VDDIO VSS VSS VSS nfet L=0.35U W=2U
Mt8esd_Mclamp_f15 VDDIO VSS VSS VSS nfet L=0.35U W=2U
Mt8esd_Mclamp_f16 VDDIO VSS VSS VSS nfet L=0.35U W=2U
Mt8esd_Mclamp_f17 VDDIO VSS VSS VSS nfet L=0.35U W=2U
Mt8esd_Mclamp_f18 VDDIO VSS VSS VSS nfet L=0.35U W=2U
Mt8esd_Mclamp_f19 VDDIO VSS VSS VSS nfet L=0.35U W=2U
Xt8esd_Resd PAD$17 PADI_T8 VSS rppd r=294.2 L=2U W=2U
Dt8esd_Dp2 PADI_T8 VDDIO dpantenna A=4P P=8U
Mt8esd_Mn2_f0 PADI_T8 VSS VSS VSS nfet L=0.13U W=1U
Mt8tx_Mi1p_f0 t8tx/OEB OE VDDIO VDDIO pfet L=0.13U W=2U
Mt8tx_Mi1n_f0 t8tx/OEB OE VSS VSS nfet L=0.13U W=1U
Mt8tx_Mnd1p_f0 t8tx/GP DIN$8 VDDIO VDDIO pfet L=0.13U W=2U
Mt8tx_Mnd1p_f1 t8tx/GP DIN$8 VDDIO VDDIO pfet L=0.13U W=2U
Mt8tx_Mnd2p_f0 t8tx/GP OE VDDIO VDDIO pfet L=0.13U W=2U
Mt8tx_Mnd2p_f1 t8tx/GP OE VDDIO VDDIO pfet L=0.13U W=2U
Mt8tx_Mnd1n_f0 t8tx/GP DIN$8 t8tx/NA VSS nfet L=0.13U W=2U
Mt8tx_Mnd1n_f1 t8tx/GP DIN$8 t8tx/NA VSS nfet L=0.13U W=2U
Mt8tx_Mnd2n_f0 t8tx/NA OE VSS VSS nfet L=0.13U W=2U
Mt8tx_Mnd2n_f1 t8tx/NA OE VSS VSS nfet L=0.13U W=2U
Mt8tx_Mnr1p_f0 t8tx/NB DIN$8 VDDIO VDDIO pfet L=0.13U W=2U
Mt8tx_Mnr1p_f1 t8tx/NB DIN$8 VDDIO VDDIO pfet L=0.13U W=2U
Mt8tx_Mnr2p_f0 t8tx/GN t8tx/OEB t8tx/NB VDDIO pfet L=0.13U W=2U
Mt8tx_Mnr2p_f1 t8tx/GN t8tx/OEB t8tx/NB VDDIO pfet L=0.13U W=2U
Mt8tx_Mnr1n_f0 t8tx/GN DIN$8 VSS VSS nfet L=0.13U W=1U
Mt8tx_Mnr1n_f1 t8tx/GN DIN$8 VSS VSS nfet L=0.13U W=1U
Mt8tx_Mnr2n_f0 t8tx/GN t8tx/OEB VSS VSS nfet L=0.13U W=1U
Mt8tx_Mnr2n_f1 t8tx/GN t8tx/OEB VSS VSS nfet L=0.13U W=1U
Mt8tx_Mp_f0 PAD$17 t8tx/GP VDDIO VDDIO pfet L=0.13U W=1U
Mt8tx_Mp_f1 PAD$17 t8tx/GP VDDIO VDDIO pfet L=0.13U W=1U
Mt8tx_Mp_f2 PAD$17 t8tx/GP VDDIO VDDIO pfet L=0.13U W=1U
Mt8tx_Mp_f3 PAD$17 t8tx/GP VDDIO VDDIO pfet L=0.13U W=1U
Mt8tx_Mp_f4 PAD$17 t8tx/GP VDDIO VDDIO pfet L=0.13U W=1U
Mt8tx_Mp_f5 PAD$17 t8tx/GP VDDIO VDDIO pfet L=0.13U W=1U
Mt8tx_Mp_f6 PAD$17 t8tx/GP VDDIO VDDIO pfet L=0.13U W=1U
Mt8tx_Mp_f7 PAD$17 t8tx/GP VDDIO VDDIO pfet L=0.13U W=1U
Mt8tx_Mp_f8 PAD$17 t8tx/GP VDDIO VDDIO pfet L=0.13U W=1U
Mt8tx_Mp_f9 PAD$17 t8tx/GP VDDIO VDDIO pfet L=0.13U W=1U
Mt8tx_Mp_f10 PAD$17 t8tx/GP VDDIO VDDIO pfet L=0.13U W=1U
Mt8tx_Mp_f11 PAD$17 t8tx/GP VDDIO VDDIO pfet L=0.13U W=1U
Mt8tx_Mp_f12 PAD$17 t8tx/GP VDDIO VDDIO pfet L=0.13U W=1U
Mt8tx_Mp_f13 PAD$17 t8tx/GP VDDIO VDDIO pfet L=0.13U W=1U
Mt8tx_Mp_f14 PAD$17 t8tx/GP VDDIO VDDIO pfet L=0.13U W=1U
Mt8tx_Mp_f15 PAD$17 t8tx/GP VDDIO VDDIO pfet L=0.13U W=1U
Mt8tx_Mp_f16 PAD$17 t8tx/GP VDDIO VDDIO pfet L=0.13U W=1U
Mt8tx_Mp_f17 PAD$17 t8tx/GP VDDIO VDDIO pfet L=0.13U W=1U
Mt8tx_Mp_f18 PAD$17 t8tx/GP VDDIO VDDIO pfet L=0.13U W=1U
Mt8tx_Mp_f19 PAD$17 t8tx/GP VDDIO VDDIO pfet L=0.13U W=1U
Mt8tx_Mp_f20 PAD$17 t8tx/GP VDDIO VDDIO pfet L=0.13U W=1U
Mt8tx_Mp_f21 PAD$17 t8tx/GP VDDIO VDDIO pfet L=0.13U W=1U
Mt8tx_Mp_f22 PAD$17 t8tx/GP VDDIO VDDIO pfet L=0.13U W=1U
Mt8tx_Mp_f23 PAD$17 t8tx/GP VDDIO VDDIO pfet L=0.13U W=1U
Mt8tx_Mp_f24 PAD$17 t8tx/GP VDDIO VDDIO pfet L=0.13U W=1U
Mt8tx_Mp_f25 PAD$17 t8tx/GP VDDIO VDDIO pfet L=0.13U W=1U
Mt8tx_Mp_f26 PAD$17 t8tx/GP VDDIO VDDIO pfet L=0.13U W=1U
Mt8tx_Mp_f27 PAD$17 t8tx/GP VDDIO VDDIO pfet L=0.13U W=1U
Mt8tx_Mn_f0 PAD$17 t8tx/GN VSS VSS nfet L=0.13U W=1U
Mt8tx_Mn_f1 PAD$17 t8tx/GN VSS VSS nfet L=0.13U W=1U
Mt8tx_Mn_f2 PAD$17 t8tx/GN VSS VSS nfet L=0.13U W=1U
Mt8tx_Mn_f3 PAD$17 t8tx/GN VSS VSS nfet L=0.13U W=1U
Mt8tx_Mn_f4 PAD$17 t8tx/GN VSS VSS nfet L=0.13U W=1U
Mt8tx_Mn_f5 PAD$17 t8tx/GN VSS VSS nfet L=0.13U W=1U
Mt8tx_Mn_f6 PAD$17 t8tx/GN VSS VSS nfet L=0.13U W=1U
Mt8tx_Mn_f7 PAD$17 t8tx/GN VSS VSS nfet L=0.13U W=1U
Mt8tx_Mn_f8 PAD$17 t8tx/GN VSS VSS nfet L=0.13U W=1U
Mt8tx_Mn_f9 PAD$17 t8tx/GN VSS VSS nfet L=0.13U W=1U
Mt8tx_Mn_f10 PAD$17 t8tx/GN VSS VSS nfet L=0.13U W=1U
Mt8tx_Mn_f11 PAD$17 t8tx/GN VSS VSS nfet L=0.13U W=1U
Mt8tx_Mn_f12 PAD$17 t8tx/GN VSS VSS nfet L=0.13U W=1U
Mt8tx_Mn_f13 PAD$17 t8tx/GN VSS VSS nfet L=0.13U W=1U
Mt8tx_Mpu_f0 t8tx/PUX PUN VDDIO VDDIO pfet L=0.13U W=2U
Xt8tx_Rpu t8tx/PUX PAD$17 VSS rppd r=12472.0 L=24U W=0.5U
Mt8tx_Mpd_f0 t8tx/PDX PD VSS VSS nfet L=0.13U W=1U
Xt8tx_Rpd PAD$17 t8tx/PDX VSS rppd r=12472.0 L=24U W=0.5U
Dt9esd_Dp1 PAD$19 VDDIO dpantenna A=100P P=40U
Dt9esd_Dn1 VSS PAD$19 dantenna A=100P P=40U
Mt9esd_Mclamp_f0 VDDIO VSS VSS VSS nfet L=0.35U W=2U
Mt9esd_Mclamp_f1 VDDIO VSS VSS VSS nfet L=0.35U W=2U
Mt9esd_Mclamp_f2 VDDIO VSS VSS VSS nfet L=0.35U W=2U
Mt9esd_Mclamp_f3 VDDIO VSS VSS VSS nfet L=0.35U W=2U
Mt9esd_Mclamp_f4 VDDIO VSS VSS VSS nfet L=0.35U W=2U
Mt9esd_Mclamp_f5 VDDIO VSS VSS VSS nfet L=0.35U W=2U
Mt9esd_Mclamp_f6 VDDIO VSS VSS VSS nfet L=0.35U W=2U
Mt9esd_Mclamp_f7 VDDIO VSS VSS VSS nfet L=0.35U W=2U
Mt9esd_Mclamp_f8 VDDIO VSS VSS VSS nfet L=0.35U W=2U
Mt9esd_Mclamp_f9 VDDIO VSS VSS VSS nfet L=0.35U W=2U
Mt9esd_Mclamp_f10 VDDIO VSS VSS VSS nfet L=0.35U W=2U
Mt9esd_Mclamp_f11 VDDIO VSS VSS VSS nfet L=0.35U W=2U
Mt9esd_Mclamp_f12 VDDIO VSS VSS VSS nfet L=0.35U W=2U
Mt9esd_Mclamp_f13 VDDIO VSS VSS VSS nfet L=0.35U W=2U
Mt9esd_Mclamp_f14 VDDIO VSS VSS VSS nfet L=0.35U W=2U
Mt9esd_Mclamp_f15 VDDIO VSS VSS VSS nfet L=0.35U W=2U
Mt9esd_Mclamp_f16 VDDIO VSS VSS VSS nfet L=0.35U W=2U
Mt9esd_Mclamp_f17 VDDIO VSS VSS VSS nfet L=0.35U W=2U
Mt9esd_Mclamp_f18 VDDIO VSS VSS VSS nfet L=0.35U W=2U
Mt9esd_Mclamp_f19 VDDIO VSS VSS VSS nfet L=0.35U W=2U
Xt9esd_Resd PAD$19 PADI_T9 VSS rppd r=294.2 L=2U W=2U
Dt9esd_Dp2 PADI_T9 VDDIO dpantenna A=4P P=8U
Mt9esd_Mn2_f0 PADI_T9 VSS VSS VSS nfet L=0.13U W=1U
Mt9tx_Mi1p_f0 t9tx/OEB OE VDDIO VDDIO pfet L=0.13U W=2U
Mt9tx_Mi1n_f0 t9tx/OEB OE VSS VSS nfet L=0.13U W=1U
Mt9tx_Mnd1p_f0 t9tx/GP DIN$9 VDDIO VDDIO pfet L=0.13U W=2U
Mt9tx_Mnd1p_f1 t9tx/GP DIN$9 VDDIO VDDIO pfet L=0.13U W=2U
Mt9tx_Mnd2p_f0 t9tx/GP OE VDDIO VDDIO pfet L=0.13U W=2U
Mt9tx_Mnd2p_f1 t9tx/GP OE VDDIO VDDIO pfet L=0.13U W=2U
Mt9tx_Mnd1n_f0 t9tx/GP DIN$9 t9tx/NA VSS nfet L=0.13U W=2U
Mt9tx_Mnd1n_f1 t9tx/GP DIN$9 t9tx/NA VSS nfet L=0.13U W=2U
Mt9tx_Mnd2n_f0 t9tx/NA OE VSS VSS nfet L=0.13U W=2U
Mt9tx_Mnd2n_f1 t9tx/NA OE VSS VSS nfet L=0.13U W=2U
Mt9tx_Mnr1p_f0 t9tx/NB DIN$9 VDDIO VDDIO pfet L=0.13U W=2U
Mt9tx_Mnr1p_f1 t9tx/NB DIN$9 VDDIO VDDIO pfet L=0.13U W=2U
Mt9tx_Mnr2p_f0 t9tx/GN t9tx/OEB t9tx/NB VDDIO pfet L=0.13U W=2U
Mt9tx_Mnr2p_f1 t9tx/GN t9tx/OEB t9tx/NB VDDIO pfet L=0.13U W=2U
Mt9tx_Mnr1n_f0 t9tx/GN DIN$9 VSS VSS nfet L=0.13U W=1U
Mt9tx_Mnr1n_f1 t9tx/GN DIN$9 VSS VSS nfet L=0.13U W=1U
Mt9tx_Mnr2n_f0 t9tx/GN t9tx/OEB VSS VSS nfet L=0.13U W=1U
Mt9tx_Mnr2n_f1 t9tx/GN t9tx/OEB VSS VSS nfet L=0.13U W=1U
Mt9tx_Mp_f0 PAD$19 t9tx/GP VDDIO VDDIO pfet L=0.13U W=1U
Mt9tx_Mp_f1 PAD$19 t9tx/GP VDDIO VDDIO pfet L=0.13U W=1U
Mt9tx_Mp_f2 PAD$19 t9tx/GP VDDIO VDDIO pfet L=0.13U W=1U
Mt9tx_Mp_f3 PAD$19 t9tx/GP VDDIO VDDIO pfet L=0.13U W=1U
Mt9tx_Mp_f4 PAD$19 t9tx/GP VDDIO VDDIO pfet L=0.13U W=1U
Mt9tx_Mp_f5 PAD$19 t9tx/GP VDDIO VDDIO pfet L=0.13U W=1U
Mt9tx_Mp_f6 PAD$19 t9tx/GP VDDIO VDDIO pfet L=0.13U W=1U
Mt9tx_Mp_f7 PAD$19 t9tx/GP VDDIO VDDIO pfet L=0.13U W=1U
Mt9tx_Mp_f8 PAD$19 t9tx/GP VDDIO VDDIO pfet L=0.13U W=1U
Mt9tx_Mp_f9 PAD$19 t9tx/GP VDDIO VDDIO pfet L=0.13U W=1U
Mt9tx_Mp_f10 PAD$19 t9tx/GP VDDIO VDDIO pfet L=0.13U W=1U
Mt9tx_Mp_f11 PAD$19 t9tx/GP VDDIO VDDIO pfet L=0.13U W=1U
Mt9tx_Mp_f12 PAD$19 t9tx/GP VDDIO VDDIO pfet L=0.13U W=1U
Mt9tx_Mp_f13 PAD$19 t9tx/GP VDDIO VDDIO pfet L=0.13U W=1U
Mt9tx_Mp_f14 PAD$19 t9tx/GP VDDIO VDDIO pfet L=0.13U W=1U
Mt9tx_Mp_f15 PAD$19 t9tx/GP VDDIO VDDIO pfet L=0.13U W=1U
Mt9tx_Mp_f16 PAD$19 t9tx/GP VDDIO VDDIO pfet L=0.13U W=1U
Mt9tx_Mp_f17 PAD$19 t9tx/GP VDDIO VDDIO pfet L=0.13U W=1U
Mt9tx_Mp_f18 PAD$19 t9tx/GP VDDIO VDDIO pfet L=0.13U W=1U
Mt9tx_Mp_f19 PAD$19 t9tx/GP VDDIO VDDIO pfet L=0.13U W=1U
Mt9tx_Mp_f20 PAD$19 t9tx/GP VDDIO VDDIO pfet L=0.13U W=1U
Mt9tx_Mp_f21 PAD$19 t9tx/GP VDDIO VDDIO pfet L=0.13U W=1U
Mt9tx_Mp_f22 PAD$19 t9tx/GP VDDIO VDDIO pfet L=0.13U W=1U
Mt9tx_Mp_f23 PAD$19 t9tx/GP VDDIO VDDIO pfet L=0.13U W=1U
Mt9tx_Mp_f24 PAD$19 t9tx/GP VDDIO VDDIO pfet L=0.13U W=1U
Mt9tx_Mp_f25 PAD$19 t9tx/GP VDDIO VDDIO pfet L=0.13U W=1U
Mt9tx_Mp_f26 PAD$19 t9tx/GP VDDIO VDDIO pfet L=0.13U W=1U
Mt9tx_Mp_f27 PAD$19 t9tx/GP VDDIO VDDIO pfet L=0.13U W=1U
Mt9tx_Mn_f0 PAD$19 t9tx/GN VSS VSS nfet L=0.13U W=1U
Mt9tx_Mn_f1 PAD$19 t9tx/GN VSS VSS nfet L=0.13U W=1U
Mt9tx_Mn_f2 PAD$19 t9tx/GN VSS VSS nfet L=0.13U W=1U
Mt9tx_Mn_f3 PAD$19 t9tx/GN VSS VSS nfet L=0.13U W=1U
Mt9tx_Mn_f4 PAD$19 t9tx/GN VSS VSS nfet L=0.13U W=1U
Mt9tx_Mn_f5 PAD$19 t9tx/GN VSS VSS nfet L=0.13U W=1U
Mt9tx_Mn_f6 PAD$19 t9tx/GN VSS VSS nfet L=0.13U W=1U
Mt9tx_Mn_f7 PAD$19 t9tx/GN VSS VSS nfet L=0.13U W=1U
Mt9tx_Mn_f8 PAD$19 t9tx/GN VSS VSS nfet L=0.13U W=1U
Mt9tx_Mn_f9 PAD$19 t9tx/GN VSS VSS nfet L=0.13U W=1U
Mt9tx_Mn_f10 PAD$19 t9tx/GN VSS VSS nfet L=0.13U W=1U
Mt9tx_Mn_f11 PAD$19 t9tx/GN VSS VSS nfet L=0.13U W=1U
Mt9tx_Mn_f12 PAD$19 t9tx/GN VSS VSS nfet L=0.13U W=1U
Mt9tx_Mn_f13 PAD$19 t9tx/GN VSS VSS nfet L=0.13U W=1U
Mt9tx_Mpu_f0 t9tx/PUX PUN VDDIO VDDIO pfet L=0.13U W=2U
Xt9tx_Rpu t9tx/PUX PAD$19 VSS rppd r=12472.0 L=24U W=0.5U
Mt9tx_Mpd_f0 t9tx/PDX PD VSS VSS nfet L=0.13U W=1U
Xt9tx_Rpd PAD$19 t9tx/PDX VSS rppd r=12472.0 L=24U W=0.5U
Dt10esd_Dp1 PAD$21 VDDIO dpantenna A=100P P=40U
Dt10esd_Dn1 VSS PAD$21 dantenna A=100P P=40U
Mt10esd_Mclamp_f0 VDDIO VSS VSS VSS nfet L=0.35U W=2U
Mt10esd_Mclamp_f1 VDDIO VSS VSS VSS nfet L=0.35U W=2U
Mt10esd_Mclamp_f2 VDDIO VSS VSS VSS nfet L=0.35U W=2U
Mt10esd_Mclamp_f3 VDDIO VSS VSS VSS nfet L=0.35U W=2U
Mt10esd_Mclamp_f4 VDDIO VSS VSS VSS nfet L=0.35U W=2U
Mt10esd_Mclamp_f5 VDDIO VSS VSS VSS nfet L=0.35U W=2U
Mt10esd_Mclamp_f6 VDDIO VSS VSS VSS nfet L=0.35U W=2U
Mt10esd_Mclamp_f7 VDDIO VSS VSS VSS nfet L=0.35U W=2U
Mt10esd_Mclamp_f8 VDDIO VSS VSS VSS nfet L=0.35U W=2U
Mt10esd_Mclamp_f9 VDDIO VSS VSS VSS nfet L=0.35U W=2U
Mt10esd_Mclamp_f10 VDDIO VSS VSS VSS nfet L=0.35U W=2U
Mt10esd_Mclamp_f11 VDDIO VSS VSS VSS nfet L=0.35U W=2U
Mt10esd_Mclamp_f12 VDDIO VSS VSS VSS nfet L=0.35U W=2U
Mt10esd_Mclamp_f13 VDDIO VSS VSS VSS nfet L=0.35U W=2U
Mt10esd_Mclamp_f14 VDDIO VSS VSS VSS nfet L=0.35U W=2U
Mt10esd_Mclamp_f15 VDDIO VSS VSS VSS nfet L=0.35U W=2U
Mt10esd_Mclamp_f16 VDDIO VSS VSS VSS nfet L=0.35U W=2U
Mt10esd_Mclamp_f17 VDDIO VSS VSS VSS nfet L=0.35U W=2U
Mt10esd_Mclamp_f18 VDDIO VSS VSS VSS nfet L=0.35U W=2U
Mt10esd_Mclamp_f19 VDDIO VSS VSS VSS nfet L=0.35U W=2U
Xt10esd_Resd PAD$21 PADI_T10 VSS rppd r=294.2 L=2U W=2U
Dt10esd_Dp2 PADI_T10 VDDIO dpantenna A=4P P=8U
Mt10esd_Mn2_f0 PADI_T10 VSS VSS VSS nfet L=0.13U W=1U
Mt10tx_Mi1p_f0 t10tx/OEB OE VDDIO VDDIO pfet L=0.13U W=2U
Mt10tx_Mi1n_f0 t10tx/OEB OE VSS VSS nfet L=0.13U W=1U
Mt10tx_Mnd1p_f0 t10tx/GP DIN$10 VDDIO VDDIO pfet L=0.13U W=2U
Mt10tx_Mnd1p_f1 t10tx/GP DIN$10 VDDIO VDDIO pfet L=0.13U W=2U
Mt10tx_Mnd2p_f0 t10tx/GP OE VDDIO VDDIO pfet L=0.13U W=2U
Mt10tx_Mnd2p_f1 t10tx/GP OE VDDIO VDDIO pfet L=0.13U W=2U
Mt10tx_Mnd1n_f0 t10tx/GP DIN$10 t10tx/NA VSS nfet L=0.13U W=2U
Mt10tx_Mnd1n_f1 t10tx/GP DIN$10 t10tx/NA VSS nfet L=0.13U W=2U
Mt10tx_Mnd2n_f0 t10tx/NA OE VSS VSS nfet L=0.13U W=2U
Mt10tx_Mnd2n_f1 t10tx/NA OE VSS VSS nfet L=0.13U W=2U
Mt10tx_Mnr1p_f0 t10tx/NB DIN$10 VDDIO VDDIO pfet L=0.13U W=2U
Mt10tx_Mnr1p_f1 t10tx/NB DIN$10 VDDIO VDDIO pfet L=0.13U W=2U
Mt10tx_Mnr2p_f0 t10tx/GN t10tx/OEB t10tx/NB VDDIO pfet L=0.13U W=2U
Mt10tx_Mnr2p_f1 t10tx/GN t10tx/OEB t10tx/NB VDDIO pfet L=0.13U W=2U
Mt10tx_Mnr1n_f0 t10tx/GN DIN$10 VSS VSS nfet L=0.13U W=1U
Mt10tx_Mnr1n_f1 t10tx/GN DIN$10 VSS VSS nfet L=0.13U W=1U
Mt10tx_Mnr2n_f0 t10tx/GN t10tx/OEB VSS VSS nfet L=0.13U W=1U
Mt10tx_Mnr2n_f1 t10tx/GN t10tx/OEB VSS VSS nfet L=0.13U W=1U
Mt10tx_Mp_f0 PAD$21 t10tx/GP VDDIO VDDIO pfet L=0.13U W=1U
Mt10tx_Mp_f1 PAD$21 t10tx/GP VDDIO VDDIO pfet L=0.13U W=1U
Mt10tx_Mp_f2 PAD$21 t10tx/GP VDDIO VDDIO pfet L=0.13U W=1U
Mt10tx_Mp_f3 PAD$21 t10tx/GP VDDIO VDDIO pfet L=0.13U W=1U
Mt10tx_Mp_f4 PAD$21 t10tx/GP VDDIO VDDIO pfet L=0.13U W=1U
Mt10tx_Mp_f5 PAD$21 t10tx/GP VDDIO VDDIO pfet L=0.13U W=1U
Mt10tx_Mp_f6 PAD$21 t10tx/GP VDDIO VDDIO pfet L=0.13U W=1U
Mt10tx_Mp_f7 PAD$21 t10tx/GP VDDIO VDDIO pfet L=0.13U W=1U
Mt10tx_Mp_f8 PAD$21 t10tx/GP VDDIO VDDIO pfet L=0.13U W=1U
Mt10tx_Mp_f9 PAD$21 t10tx/GP VDDIO VDDIO pfet L=0.13U W=1U
Mt10tx_Mp_f10 PAD$21 t10tx/GP VDDIO VDDIO pfet L=0.13U W=1U
Mt10tx_Mp_f11 PAD$21 t10tx/GP VDDIO VDDIO pfet L=0.13U W=1U
Mt10tx_Mp_f12 PAD$21 t10tx/GP VDDIO VDDIO pfet L=0.13U W=1U
Mt10tx_Mp_f13 PAD$21 t10tx/GP VDDIO VDDIO pfet L=0.13U W=1U
Mt10tx_Mp_f14 PAD$21 t10tx/GP VDDIO VDDIO pfet L=0.13U W=1U
Mt10tx_Mp_f15 PAD$21 t10tx/GP VDDIO VDDIO pfet L=0.13U W=1U
Mt10tx_Mp_f16 PAD$21 t10tx/GP VDDIO VDDIO pfet L=0.13U W=1U
Mt10tx_Mp_f17 PAD$21 t10tx/GP VDDIO VDDIO pfet L=0.13U W=1U
Mt10tx_Mp_f18 PAD$21 t10tx/GP VDDIO VDDIO pfet L=0.13U W=1U
Mt10tx_Mp_f19 PAD$21 t10tx/GP VDDIO VDDIO pfet L=0.13U W=1U
Mt10tx_Mp_f20 PAD$21 t10tx/GP VDDIO VDDIO pfet L=0.13U W=1U
Mt10tx_Mp_f21 PAD$21 t10tx/GP VDDIO VDDIO pfet L=0.13U W=1U
Mt10tx_Mp_f22 PAD$21 t10tx/GP VDDIO VDDIO pfet L=0.13U W=1U
Mt10tx_Mp_f23 PAD$21 t10tx/GP VDDIO VDDIO pfet L=0.13U W=1U
Mt10tx_Mp_f24 PAD$21 t10tx/GP VDDIO VDDIO pfet L=0.13U W=1U
Mt10tx_Mp_f25 PAD$21 t10tx/GP VDDIO VDDIO pfet L=0.13U W=1U
Mt10tx_Mp_f26 PAD$21 t10tx/GP VDDIO VDDIO pfet L=0.13U W=1U
Mt10tx_Mp_f27 PAD$21 t10tx/GP VDDIO VDDIO pfet L=0.13U W=1U
Mt10tx_Mn_f0 PAD$21 t10tx/GN VSS VSS nfet L=0.13U W=1U
Mt10tx_Mn_f1 PAD$21 t10tx/GN VSS VSS nfet L=0.13U W=1U
Mt10tx_Mn_f2 PAD$21 t10tx/GN VSS VSS nfet L=0.13U W=1U
Mt10tx_Mn_f3 PAD$21 t10tx/GN VSS VSS nfet L=0.13U W=1U
Mt10tx_Mn_f4 PAD$21 t10tx/GN VSS VSS nfet L=0.13U W=1U
Mt10tx_Mn_f5 PAD$21 t10tx/GN VSS VSS nfet L=0.13U W=1U
Mt10tx_Mn_f6 PAD$21 t10tx/GN VSS VSS nfet L=0.13U W=1U
Mt10tx_Mn_f7 PAD$21 t10tx/GN VSS VSS nfet L=0.13U W=1U
Mt10tx_Mn_f8 PAD$21 t10tx/GN VSS VSS nfet L=0.13U W=1U
Mt10tx_Mn_f9 PAD$21 t10tx/GN VSS VSS nfet L=0.13U W=1U
Mt10tx_Mn_f10 PAD$21 t10tx/GN VSS VSS nfet L=0.13U W=1U
Mt10tx_Mn_f11 PAD$21 t10tx/GN VSS VSS nfet L=0.13U W=1U
Mt10tx_Mn_f12 PAD$21 t10tx/GN VSS VSS nfet L=0.13U W=1U
Mt10tx_Mn_f13 PAD$21 t10tx/GN VSS VSS nfet L=0.13U W=1U
Mt10tx_Mpu_f0 t10tx/PUX PUN VDDIO VDDIO pfet L=0.13U W=2U
Xt10tx_Rpu t10tx/PUX PAD$21 VSS rppd r=12472.0 L=24U W=0.5U
Mt10tx_Mpd_f0 t10tx/PDX PD VSS VSS nfet L=0.13U W=1U
Xt10tx_Rpd PAD$21 t10tx/PDX VSS rppd r=12472.0 L=24U W=0.5U
Dt11esd_Dp1 PAD$23 VDDIO dpantenna A=100P P=40U
Dt11esd_Dn1 VSS PAD$23 dantenna A=100P P=40U
Mt11esd_Mclamp_f0 VDDIO VSS VSS VSS nfet L=0.35U W=2U
Mt11esd_Mclamp_f1 VDDIO VSS VSS VSS nfet L=0.35U W=2U
Mt11esd_Mclamp_f2 VDDIO VSS VSS VSS nfet L=0.35U W=2U
Mt11esd_Mclamp_f3 VDDIO VSS VSS VSS nfet L=0.35U W=2U
Mt11esd_Mclamp_f4 VDDIO VSS VSS VSS nfet L=0.35U W=2U
Mt11esd_Mclamp_f5 VDDIO VSS VSS VSS nfet L=0.35U W=2U
Mt11esd_Mclamp_f6 VDDIO VSS VSS VSS nfet L=0.35U W=2U
Mt11esd_Mclamp_f7 VDDIO VSS VSS VSS nfet L=0.35U W=2U
Mt11esd_Mclamp_f8 VDDIO VSS VSS VSS nfet L=0.35U W=2U
Mt11esd_Mclamp_f9 VDDIO VSS VSS VSS nfet L=0.35U W=2U
Mt11esd_Mclamp_f10 VDDIO VSS VSS VSS nfet L=0.35U W=2U
Mt11esd_Mclamp_f11 VDDIO VSS VSS VSS nfet L=0.35U W=2U
Mt11esd_Mclamp_f12 VDDIO VSS VSS VSS nfet L=0.35U W=2U
Mt11esd_Mclamp_f13 VDDIO VSS VSS VSS nfet L=0.35U W=2U
Mt11esd_Mclamp_f14 VDDIO VSS VSS VSS nfet L=0.35U W=2U
Mt11esd_Mclamp_f15 VDDIO VSS VSS VSS nfet L=0.35U W=2U
Mt11esd_Mclamp_f16 VDDIO VSS VSS VSS nfet L=0.35U W=2U
Mt11esd_Mclamp_f17 VDDIO VSS VSS VSS nfet L=0.35U W=2U
Mt11esd_Mclamp_f18 VDDIO VSS VSS VSS nfet L=0.35U W=2U
Mt11esd_Mclamp_f19 VDDIO VSS VSS VSS nfet L=0.35U W=2U
Xt11esd_Resd PAD$23 PADI_T11 VSS rppd r=294.2 L=2U W=2U
Dt11esd_Dp2 PADI_T11 VDDIO dpantenna A=4P P=8U
Mt11esd_Mn2_f0 PADI_T11 VSS VSS VSS nfet L=0.13U W=1U
Mt11tx_Mi1p_f0 t11tx/OEB OE VDDIO VDDIO pfet L=0.13U W=2U
Mt11tx_Mi1n_f0 t11tx/OEB OE VSS VSS nfet L=0.13U W=1U
Mt11tx_Mnd1p_f0 t11tx/GP DIN$11 VDDIO VDDIO pfet L=0.13U W=2U
Mt11tx_Mnd1p_f1 t11tx/GP DIN$11 VDDIO VDDIO pfet L=0.13U W=2U
Mt11tx_Mnd2p_f0 t11tx/GP OE VDDIO VDDIO pfet L=0.13U W=2U
Mt11tx_Mnd2p_f1 t11tx/GP OE VDDIO VDDIO pfet L=0.13U W=2U
Mt11tx_Mnd1n_f0 t11tx/GP DIN$11 t11tx/NA VSS nfet L=0.13U W=2U
Mt11tx_Mnd1n_f1 t11tx/GP DIN$11 t11tx/NA VSS nfet L=0.13U W=2U
Mt11tx_Mnd2n_f0 t11tx/NA OE VSS VSS nfet L=0.13U W=2U
Mt11tx_Mnd2n_f1 t11tx/NA OE VSS VSS nfet L=0.13U W=2U
Mt11tx_Mnr1p_f0 t11tx/NB DIN$11 VDDIO VDDIO pfet L=0.13U W=2U
Mt11tx_Mnr1p_f1 t11tx/NB DIN$11 VDDIO VDDIO pfet L=0.13U W=2U
Mt11tx_Mnr2p_f0 t11tx/GN t11tx/OEB t11tx/NB VDDIO pfet L=0.13U W=2U
Mt11tx_Mnr2p_f1 t11tx/GN t11tx/OEB t11tx/NB VDDIO pfet L=0.13U W=2U
Mt11tx_Mnr1n_f0 t11tx/GN DIN$11 VSS VSS nfet L=0.13U W=1U
Mt11tx_Mnr1n_f1 t11tx/GN DIN$11 VSS VSS nfet L=0.13U W=1U
Mt11tx_Mnr2n_f0 t11tx/GN t11tx/OEB VSS VSS nfet L=0.13U W=1U
Mt11tx_Mnr2n_f1 t11tx/GN t11tx/OEB VSS VSS nfet L=0.13U W=1U
Mt11tx_Mp_f0 PAD$23 t11tx/GP VDDIO VDDIO pfet L=0.13U W=1U
Mt11tx_Mp_f1 PAD$23 t11tx/GP VDDIO VDDIO pfet L=0.13U W=1U
Mt11tx_Mp_f2 PAD$23 t11tx/GP VDDIO VDDIO pfet L=0.13U W=1U
Mt11tx_Mp_f3 PAD$23 t11tx/GP VDDIO VDDIO pfet L=0.13U W=1U
Mt11tx_Mp_f4 PAD$23 t11tx/GP VDDIO VDDIO pfet L=0.13U W=1U
Mt11tx_Mp_f5 PAD$23 t11tx/GP VDDIO VDDIO pfet L=0.13U W=1U
Mt11tx_Mp_f6 PAD$23 t11tx/GP VDDIO VDDIO pfet L=0.13U W=1U
Mt11tx_Mp_f7 PAD$23 t11tx/GP VDDIO VDDIO pfet L=0.13U W=1U
Mt11tx_Mp_f8 PAD$23 t11tx/GP VDDIO VDDIO pfet L=0.13U W=1U
Mt11tx_Mp_f9 PAD$23 t11tx/GP VDDIO VDDIO pfet L=0.13U W=1U
Mt11tx_Mp_f10 PAD$23 t11tx/GP VDDIO VDDIO pfet L=0.13U W=1U
Mt11tx_Mp_f11 PAD$23 t11tx/GP VDDIO VDDIO pfet L=0.13U W=1U
Mt11tx_Mp_f12 PAD$23 t11tx/GP VDDIO VDDIO pfet L=0.13U W=1U
Mt11tx_Mp_f13 PAD$23 t11tx/GP VDDIO VDDIO pfet L=0.13U W=1U
Mt11tx_Mp_f14 PAD$23 t11tx/GP VDDIO VDDIO pfet L=0.13U W=1U
Mt11tx_Mp_f15 PAD$23 t11tx/GP VDDIO VDDIO pfet L=0.13U W=1U
Mt11tx_Mp_f16 PAD$23 t11tx/GP VDDIO VDDIO pfet L=0.13U W=1U
Mt11tx_Mp_f17 PAD$23 t11tx/GP VDDIO VDDIO pfet L=0.13U W=1U
Mt11tx_Mp_f18 PAD$23 t11tx/GP VDDIO VDDIO pfet L=0.13U W=1U
Mt11tx_Mp_f19 PAD$23 t11tx/GP VDDIO VDDIO pfet L=0.13U W=1U
Mt11tx_Mp_f20 PAD$23 t11tx/GP VDDIO VDDIO pfet L=0.13U W=1U
Mt11tx_Mp_f21 PAD$23 t11tx/GP VDDIO VDDIO pfet L=0.13U W=1U
Mt11tx_Mp_f22 PAD$23 t11tx/GP VDDIO VDDIO pfet L=0.13U W=1U
Mt11tx_Mp_f23 PAD$23 t11tx/GP VDDIO VDDIO pfet L=0.13U W=1U
Mt11tx_Mp_f24 PAD$23 t11tx/GP VDDIO VDDIO pfet L=0.13U W=1U
Mt11tx_Mp_f25 PAD$23 t11tx/GP VDDIO VDDIO pfet L=0.13U W=1U
Mt11tx_Mp_f26 PAD$23 t11tx/GP VDDIO VDDIO pfet L=0.13U W=1U
Mt11tx_Mp_f27 PAD$23 t11tx/GP VDDIO VDDIO pfet L=0.13U W=1U
Mt11tx_Mn_f0 PAD$23 t11tx/GN VSS VSS nfet L=0.13U W=1U
Mt11tx_Mn_f1 PAD$23 t11tx/GN VSS VSS nfet L=0.13U W=1U
Mt11tx_Mn_f2 PAD$23 t11tx/GN VSS VSS nfet L=0.13U W=1U
Mt11tx_Mn_f3 PAD$23 t11tx/GN VSS VSS nfet L=0.13U W=1U
Mt11tx_Mn_f4 PAD$23 t11tx/GN VSS VSS nfet L=0.13U W=1U
Mt11tx_Mn_f5 PAD$23 t11tx/GN VSS VSS nfet L=0.13U W=1U
Mt11tx_Mn_f6 PAD$23 t11tx/GN VSS VSS nfet L=0.13U W=1U
Mt11tx_Mn_f7 PAD$23 t11tx/GN VSS VSS nfet L=0.13U W=1U
Mt11tx_Mn_f8 PAD$23 t11tx/GN VSS VSS nfet L=0.13U W=1U
Mt11tx_Mn_f9 PAD$23 t11tx/GN VSS VSS nfet L=0.13U W=1U
Mt11tx_Mn_f10 PAD$23 t11tx/GN VSS VSS nfet L=0.13U W=1U
Mt11tx_Mn_f11 PAD$23 t11tx/GN VSS VSS nfet L=0.13U W=1U
Mt11tx_Mn_f12 PAD$23 t11tx/GN VSS VSS nfet L=0.13U W=1U
Mt11tx_Mn_f13 PAD$23 t11tx/GN VSS VSS nfet L=0.13U W=1U
Mt11tx_Mpu_f0 t11tx/PUX PUN VDDIO VDDIO pfet L=0.13U W=2U
Xt11tx_Rpu t11tx/PUX PAD$23 VSS rppd r=12472.0 L=24U W=0.5U
Mt11tx_Mpd_f0 t11tx/PDX PD VSS VSS nfet L=0.13U W=1U
Xt11tx_Rpd PAD$23 t11tx/PDX VSS rppd r=12472.0 L=24U W=0.5U
Dt12esd_Dp1 PAD VDDIO dpantenna A=100P P=40U
Dt12esd_Dn1 VSS PAD dantenna A=100P P=40U
Mt12esd_Mclamp_f0 VDDIO VSS VSS VSS nfet L=0.35U W=2U
Mt12esd_Mclamp_f1 VDDIO VSS VSS VSS nfet L=0.35U W=2U
Mt12esd_Mclamp_f2 VDDIO VSS VSS VSS nfet L=0.35U W=2U
Mt12esd_Mclamp_f3 VDDIO VSS VSS VSS nfet L=0.35U W=2U
Mt12esd_Mclamp_f4 VDDIO VSS VSS VSS nfet L=0.35U W=2U
Mt12esd_Mclamp_f5 VDDIO VSS VSS VSS nfet L=0.35U W=2U
Mt12esd_Mclamp_f6 VDDIO VSS VSS VSS nfet L=0.35U W=2U
Mt12esd_Mclamp_f7 VDDIO VSS VSS VSS nfet L=0.35U W=2U
Mt12esd_Mclamp_f8 VDDIO VSS VSS VSS nfet L=0.35U W=2U
Mt12esd_Mclamp_f9 VDDIO VSS VSS VSS nfet L=0.35U W=2U
Mt12esd_Mclamp_f10 VDDIO VSS VSS VSS nfet L=0.35U W=2U
Mt12esd_Mclamp_f11 VDDIO VSS VSS VSS nfet L=0.35U W=2U
Mt12esd_Mclamp_f12 VDDIO VSS VSS VSS nfet L=0.35U W=2U
Mt12esd_Mclamp_f13 VDDIO VSS VSS VSS nfet L=0.35U W=2U
Mt12esd_Mclamp_f14 VDDIO VSS VSS VSS nfet L=0.35U W=2U
Mt12esd_Mclamp_f15 VDDIO VSS VSS VSS nfet L=0.35U W=2U
Mt12esd_Mclamp_f16 VDDIO VSS VSS VSS nfet L=0.35U W=2U
Mt12esd_Mclamp_f17 VDDIO VSS VSS VSS nfet L=0.35U W=2U
Mt12esd_Mclamp_f18 VDDIO VSS VSS VSS nfet L=0.35U W=2U
Mt12esd_Mclamp_f19 VDDIO VSS VSS VSS nfet L=0.35U W=2U
Xt12esd_Resd PAD PADI_T12 VSS rppd r=294.2 L=2U W=2U
Dt12esd_Dp2 PADI_T12 VDDIO dpantenna A=4P P=8U
Mt12esd_Mn2_f0 PADI_T12 VSS VSS VSS nfet L=0.13U W=1U
Mt12tx_Mi1p_f0 t12tx/OEB OE VDDIO VDDIO pfet L=0.13U W=2U
Mt12tx_Mi1n_f0 t12tx/OEB OE VSS VSS nfet L=0.13U W=1U
Mt12tx_Mnd1p_f0 t12tx/GP DIN$12 VDDIO VDDIO pfet L=0.13U W=2U
Mt12tx_Mnd1p_f1 t12tx/GP DIN$12 VDDIO VDDIO pfet L=0.13U W=2U
Mt12tx_Mnd2p_f0 t12tx/GP OE VDDIO VDDIO pfet L=0.13U W=2U
Mt12tx_Mnd2p_f1 t12tx/GP OE VDDIO VDDIO pfet L=0.13U W=2U
Mt12tx_Mnd1n_f0 t12tx/GP DIN$12 t12tx/NA VSS nfet L=0.13U W=2U
Mt12tx_Mnd1n_f1 t12tx/GP DIN$12 t12tx/NA VSS nfet L=0.13U W=2U
Mt12tx_Mnd2n_f0 t12tx/NA OE VSS VSS nfet L=0.13U W=2U
Mt12tx_Mnd2n_f1 t12tx/NA OE VSS VSS nfet L=0.13U W=2U
Mt12tx_Mnr1p_f0 t12tx/NB DIN$12 VDDIO VDDIO pfet L=0.13U W=2U
Mt12tx_Mnr1p_f1 t12tx/NB DIN$12 VDDIO VDDIO pfet L=0.13U W=2U
Mt12tx_Mnr2p_f0 t12tx/GN t12tx/OEB t12tx/NB VDDIO pfet L=0.13U W=2U
Mt12tx_Mnr2p_f1 t12tx/GN t12tx/OEB t12tx/NB VDDIO pfet L=0.13U W=2U
Mt12tx_Mnr1n_f0 t12tx/GN DIN$12 VSS VSS nfet L=0.13U W=1U
Mt12tx_Mnr1n_f1 t12tx/GN DIN$12 VSS VSS nfet L=0.13U W=1U
Mt12tx_Mnr2n_f0 t12tx/GN t12tx/OEB VSS VSS nfet L=0.13U W=1U
Mt12tx_Mnr2n_f1 t12tx/GN t12tx/OEB VSS VSS nfet L=0.13U W=1U
Mt12tx_Mp_f0 PAD t12tx/GP VDDIO VDDIO pfet L=0.13U W=1U
Mt12tx_Mp_f1 PAD t12tx/GP VDDIO VDDIO pfet L=0.13U W=1U
Mt12tx_Mp_f2 PAD t12tx/GP VDDIO VDDIO pfet L=0.13U W=1U
Mt12tx_Mp_f3 PAD t12tx/GP VDDIO VDDIO pfet L=0.13U W=1U
Mt12tx_Mp_f4 PAD t12tx/GP VDDIO VDDIO pfet L=0.13U W=1U
Mt12tx_Mp_f5 PAD t12tx/GP VDDIO VDDIO pfet L=0.13U W=1U
Mt12tx_Mp_f6 PAD t12tx/GP VDDIO VDDIO pfet L=0.13U W=1U
Mt12tx_Mp_f7 PAD t12tx/GP VDDIO VDDIO pfet L=0.13U W=1U
Mt12tx_Mp_f8 PAD t12tx/GP VDDIO VDDIO pfet L=0.13U W=1U
Mt12tx_Mp_f9 PAD t12tx/GP VDDIO VDDIO pfet L=0.13U W=1U
Mt12tx_Mp_f10 PAD t12tx/GP VDDIO VDDIO pfet L=0.13U W=1U
Mt12tx_Mp_f11 PAD t12tx/GP VDDIO VDDIO pfet L=0.13U W=1U
Mt12tx_Mp_f12 PAD t12tx/GP VDDIO VDDIO pfet L=0.13U W=1U
Mt12tx_Mp_f13 PAD t12tx/GP VDDIO VDDIO pfet L=0.13U W=1U
Mt12tx_Mp_f14 PAD t12tx/GP VDDIO VDDIO pfet L=0.13U W=1U
Mt12tx_Mp_f15 PAD t12tx/GP VDDIO VDDIO pfet L=0.13U W=1U
Mt12tx_Mp_f16 PAD t12tx/GP VDDIO VDDIO pfet L=0.13U W=1U
Mt12tx_Mp_f17 PAD t12tx/GP VDDIO VDDIO pfet L=0.13U W=1U
Mt12tx_Mp_f18 PAD t12tx/GP VDDIO VDDIO pfet L=0.13U W=1U
Mt12tx_Mp_f19 PAD t12tx/GP VDDIO VDDIO pfet L=0.13U W=1U
Mt12tx_Mp_f20 PAD t12tx/GP VDDIO VDDIO pfet L=0.13U W=1U
Mt12tx_Mp_f21 PAD t12tx/GP VDDIO VDDIO pfet L=0.13U W=1U
Mt12tx_Mp_f22 PAD t12tx/GP VDDIO VDDIO pfet L=0.13U W=1U
Mt12tx_Mp_f23 PAD t12tx/GP VDDIO VDDIO pfet L=0.13U W=1U
Mt12tx_Mp_f24 PAD t12tx/GP VDDIO VDDIO pfet L=0.13U W=1U
Mt12tx_Mp_f25 PAD t12tx/GP VDDIO VDDIO pfet L=0.13U W=1U
Mt12tx_Mp_f26 PAD t12tx/GP VDDIO VDDIO pfet L=0.13U W=1U
Mt12tx_Mp_f27 PAD t12tx/GP VDDIO VDDIO pfet L=0.13U W=1U
Mt12tx_Mn_f0 PAD t12tx/GN VSS VSS nfet L=0.13U W=1U
Mt12tx_Mn_f1 PAD t12tx/GN VSS VSS nfet L=0.13U W=1U
Mt12tx_Mn_f2 PAD t12tx/GN VSS VSS nfet L=0.13U W=1U
Mt12tx_Mn_f3 PAD t12tx/GN VSS VSS nfet L=0.13U W=1U
Mt12tx_Mn_f4 PAD t12tx/GN VSS VSS nfet L=0.13U W=1U
Mt12tx_Mn_f5 PAD t12tx/GN VSS VSS nfet L=0.13U W=1U
Mt12tx_Mn_f6 PAD t12tx/GN VSS VSS nfet L=0.13U W=1U
Mt12tx_Mn_f7 PAD t12tx/GN VSS VSS nfet L=0.13U W=1U
Mt12tx_Mn_f8 PAD t12tx/GN VSS VSS nfet L=0.13U W=1U
Mt12tx_Mn_f9 PAD t12tx/GN VSS VSS nfet L=0.13U W=1U
Mt12tx_Mn_f10 PAD t12tx/GN VSS VSS nfet L=0.13U W=1U
Mt12tx_Mn_f11 PAD t12tx/GN VSS VSS nfet L=0.13U W=1U
Mt12tx_Mn_f12 PAD t12tx/GN VSS VSS nfet L=0.13U W=1U
Mt12tx_Mn_f13 PAD t12tx/GN VSS VSS nfet L=0.13U W=1U
Mt12tx_Mpu_f0 t12tx/PUX PUN VDDIO VDDIO pfet L=0.13U W=2U
Xt12tx_Rpu t12tx/PUX PAD VSS rppd r=12472.0 L=24U W=0.5U
Mt12tx_Mpd_f0 t12tx/PDX PD VSS VSS nfet L=0.13U W=1U
Xt12tx_Rpd PAD t12tx/PDX VSS rppd r=12472.0 L=24U W=0.5U
Dt13esd_Dp1 PAD$2 VDDIO dpantenna A=100P P=40U
Dt13esd_Dn1 VSS PAD$2 dantenna A=100P P=40U
Mt13esd_Mclamp_f0 VDDIO VSS VSS VSS nfet L=0.35U W=2U
Mt13esd_Mclamp_f1 VDDIO VSS VSS VSS nfet L=0.35U W=2U
Mt13esd_Mclamp_f2 VDDIO VSS VSS VSS nfet L=0.35U W=2U
Mt13esd_Mclamp_f3 VDDIO VSS VSS VSS nfet L=0.35U W=2U
Mt13esd_Mclamp_f4 VDDIO VSS VSS VSS nfet L=0.35U W=2U
Mt13esd_Mclamp_f5 VDDIO VSS VSS VSS nfet L=0.35U W=2U
Mt13esd_Mclamp_f6 VDDIO VSS VSS VSS nfet L=0.35U W=2U
Mt13esd_Mclamp_f7 VDDIO VSS VSS VSS nfet L=0.35U W=2U
Mt13esd_Mclamp_f8 VDDIO VSS VSS VSS nfet L=0.35U W=2U
Mt13esd_Mclamp_f9 VDDIO VSS VSS VSS nfet L=0.35U W=2U
Mt13esd_Mclamp_f10 VDDIO VSS VSS VSS nfet L=0.35U W=2U
Mt13esd_Mclamp_f11 VDDIO VSS VSS VSS nfet L=0.35U W=2U
Mt13esd_Mclamp_f12 VDDIO VSS VSS VSS nfet L=0.35U W=2U
Mt13esd_Mclamp_f13 VDDIO VSS VSS VSS nfet L=0.35U W=2U
Mt13esd_Mclamp_f14 VDDIO VSS VSS VSS nfet L=0.35U W=2U
Mt13esd_Mclamp_f15 VDDIO VSS VSS VSS nfet L=0.35U W=2U
Mt13esd_Mclamp_f16 VDDIO VSS VSS VSS nfet L=0.35U W=2U
Mt13esd_Mclamp_f17 VDDIO VSS VSS VSS nfet L=0.35U W=2U
Mt13esd_Mclamp_f18 VDDIO VSS VSS VSS nfet L=0.35U W=2U
Mt13esd_Mclamp_f19 VDDIO VSS VSS VSS nfet L=0.35U W=2U
Xt13esd_Resd PAD$2 PADI_T13 VSS rppd r=294.2 L=2U W=2U
Dt13esd_Dp2 PADI_T13 VDDIO dpantenna A=4P P=8U
Mt13esd_Mn2_f0 PADI_T13 VSS VSS VSS nfet L=0.13U W=1U
Mt13tx_Mi1p_f0 t13tx/OEB OE VDDIO VDDIO pfet L=0.13U W=2U
Mt13tx_Mi1n_f0 t13tx/OEB OE VSS VSS nfet L=0.13U W=1U
Mt13tx_Mnd1p_f0 t13tx/GP DIN$13 VDDIO VDDIO pfet L=0.13U W=2U
Mt13tx_Mnd1p_f1 t13tx/GP DIN$13 VDDIO VDDIO pfet L=0.13U W=2U
Mt13tx_Mnd2p_f0 t13tx/GP OE VDDIO VDDIO pfet L=0.13U W=2U
Mt13tx_Mnd2p_f1 t13tx/GP OE VDDIO VDDIO pfet L=0.13U W=2U
Mt13tx_Mnd1n_f0 t13tx/GP DIN$13 t13tx/NA VSS nfet L=0.13U W=2U
Mt13tx_Mnd1n_f1 t13tx/GP DIN$13 t13tx/NA VSS nfet L=0.13U W=2U
Mt13tx_Mnd2n_f0 t13tx/NA OE VSS VSS nfet L=0.13U W=2U
Mt13tx_Mnd2n_f1 t13tx/NA OE VSS VSS nfet L=0.13U W=2U
Mt13tx_Mnr1p_f0 t13tx/NB DIN$13 VDDIO VDDIO pfet L=0.13U W=2U
Mt13tx_Mnr1p_f1 t13tx/NB DIN$13 VDDIO VDDIO pfet L=0.13U W=2U
Mt13tx_Mnr2p_f0 t13tx/GN t13tx/OEB t13tx/NB VDDIO pfet L=0.13U W=2U
Mt13tx_Mnr2p_f1 t13tx/GN t13tx/OEB t13tx/NB VDDIO pfet L=0.13U W=2U
Mt13tx_Mnr1n_f0 t13tx/GN DIN$13 VSS VSS nfet L=0.13U W=1U
Mt13tx_Mnr1n_f1 t13tx/GN DIN$13 VSS VSS nfet L=0.13U W=1U
Mt13tx_Mnr2n_f0 t13tx/GN t13tx/OEB VSS VSS nfet L=0.13U W=1U
Mt13tx_Mnr2n_f1 t13tx/GN t13tx/OEB VSS VSS nfet L=0.13U W=1U
Mt13tx_Mp_f0 PAD$2 t13tx/GP VDDIO VDDIO pfet L=0.13U W=1U
Mt13tx_Mp_f1 PAD$2 t13tx/GP VDDIO VDDIO pfet L=0.13U W=1U
Mt13tx_Mp_f2 PAD$2 t13tx/GP VDDIO VDDIO pfet L=0.13U W=1U
Mt13tx_Mp_f3 PAD$2 t13tx/GP VDDIO VDDIO pfet L=0.13U W=1U
Mt13tx_Mp_f4 PAD$2 t13tx/GP VDDIO VDDIO pfet L=0.13U W=1U
Mt13tx_Mp_f5 PAD$2 t13tx/GP VDDIO VDDIO pfet L=0.13U W=1U
Mt13tx_Mp_f6 PAD$2 t13tx/GP VDDIO VDDIO pfet L=0.13U W=1U
Mt13tx_Mp_f7 PAD$2 t13tx/GP VDDIO VDDIO pfet L=0.13U W=1U
Mt13tx_Mp_f8 PAD$2 t13tx/GP VDDIO VDDIO pfet L=0.13U W=1U
Mt13tx_Mp_f9 PAD$2 t13tx/GP VDDIO VDDIO pfet L=0.13U W=1U
Mt13tx_Mp_f10 PAD$2 t13tx/GP VDDIO VDDIO pfet L=0.13U W=1U
Mt13tx_Mp_f11 PAD$2 t13tx/GP VDDIO VDDIO pfet L=0.13U W=1U
Mt13tx_Mp_f12 PAD$2 t13tx/GP VDDIO VDDIO pfet L=0.13U W=1U
Mt13tx_Mp_f13 PAD$2 t13tx/GP VDDIO VDDIO pfet L=0.13U W=1U
Mt13tx_Mp_f14 PAD$2 t13tx/GP VDDIO VDDIO pfet L=0.13U W=1U
Mt13tx_Mp_f15 PAD$2 t13tx/GP VDDIO VDDIO pfet L=0.13U W=1U
Mt13tx_Mp_f16 PAD$2 t13tx/GP VDDIO VDDIO pfet L=0.13U W=1U
Mt13tx_Mp_f17 PAD$2 t13tx/GP VDDIO VDDIO pfet L=0.13U W=1U
Mt13tx_Mp_f18 PAD$2 t13tx/GP VDDIO VDDIO pfet L=0.13U W=1U
Mt13tx_Mp_f19 PAD$2 t13tx/GP VDDIO VDDIO pfet L=0.13U W=1U
Mt13tx_Mp_f20 PAD$2 t13tx/GP VDDIO VDDIO pfet L=0.13U W=1U
Mt13tx_Mp_f21 PAD$2 t13tx/GP VDDIO VDDIO pfet L=0.13U W=1U
Mt13tx_Mp_f22 PAD$2 t13tx/GP VDDIO VDDIO pfet L=0.13U W=1U
Mt13tx_Mp_f23 PAD$2 t13tx/GP VDDIO VDDIO pfet L=0.13U W=1U
Mt13tx_Mp_f24 PAD$2 t13tx/GP VDDIO VDDIO pfet L=0.13U W=1U
Mt13tx_Mp_f25 PAD$2 t13tx/GP VDDIO VDDIO pfet L=0.13U W=1U
Mt13tx_Mp_f26 PAD$2 t13tx/GP VDDIO VDDIO pfet L=0.13U W=1U
Mt13tx_Mp_f27 PAD$2 t13tx/GP VDDIO VDDIO pfet L=0.13U W=1U
Mt13tx_Mn_f0 PAD$2 t13tx/GN VSS VSS nfet L=0.13U W=1U
Mt13tx_Mn_f1 PAD$2 t13tx/GN VSS VSS nfet L=0.13U W=1U
Mt13tx_Mn_f2 PAD$2 t13tx/GN VSS VSS nfet L=0.13U W=1U
Mt13tx_Mn_f3 PAD$2 t13tx/GN VSS VSS nfet L=0.13U W=1U
Mt13tx_Mn_f4 PAD$2 t13tx/GN VSS VSS nfet L=0.13U W=1U
Mt13tx_Mn_f5 PAD$2 t13tx/GN VSS VSS nfet L=0.13U W=1U
Mt13tx_Mn_f6 PAD$2 t13tx/GN VSS VSS nfet L=0.13U W=1U
Mt13tx_Mn_f7 PAD$2 t13tx/GN VSS VSS nfet L=0.13U W=1U
Mt13tx_Mn_f8 PAD$2 t13tx/GN VSS VSS nfet L=0.13U W=1U
Mt13tx_Mn_f9 PAD$2 t13tx/GN VSS VSS nfet L=0.13U W=1U
Mt13tx_Mn_f10 PAD$2 t13tx/GN VSS VSS nfet L=0.13U W=1U
Mt13tx_Mn_f11 PAD$2 t13tx/GN VSS VSS nfet L=0.13U W=1U
Mt13tx_Mn_f12 PAD$2 t13tx/GN VSS VSS nfet L=0.13U W=1U
Mt13tx_Mn_f13 PAD$2 t13tx/GN VSS VSS nfet L=0.13U W=1U
Mt13tx_Mpu_f0 t13tx/PUX PUN VDDIO VDDIO pfet L=0.13U W=2U
Xt13tx_Rpu t13tx/PUX PAD$2 VSS rppd r=12472.0 L=24U W=0.5U
Mt13tx_Mpd_f0 t13tx/PDX PD VSS VSS nfet L=0.13U W=1U
Xt13tx_Rpd PAD$2 t13tx/PDX VSS rppd r=12472.0 L=24U W=0.5U
Dt14esd_Dp1 PAD$4 VDDIO dpantenna A=100P P=40U
Dt14esd_Dn1 VSS PAD$4 dantenna A=100P P=40U
Mt14esd_Mclamp_f0 VDDIO VSS VSS VSS nfet L=0.35U W=2U
Mt14esd_Mclamp_f1 VDDIO VSS VSS VSS nfet L=0.35U W=2U
Mt14esd_Mclamp_f2 VDDIO VSS VSS VSS nfet L=0.35U W=2U
Mt14esd_Mclamp_f3 VDDIO VSS VSS VSS nfet L=0.35U W=2U
Mt14esd_Mclamp_f4 VDDIO VSS VSS VSS nfet L=0.35U W=2U
Mt14esd_Mclamp_f5 VDDIO VSS VSS VSS nfet L=0.35U W=2U
Mt14esd_Mclamp_f6 VDDIO VSS VSS VSS nfet L=0.35U W=2U
Mt14esd_Mclamp_f7 VDDIO VSS VSS VSS nfet L=0.35U W=2U
Mt14esd_Mclamp_f8 VDDIO VSS VSS VSS nfet L=0.35U W=2U
Mt14esd_Mclamp_f9 VDDIO VSS VSS VSS nfet L=0.35U W=2U
Mt14esd_Mclamp_f10 VDDIO VSS VSS VSS nfet L=0.35U W=2U
Mt14esd_Mclamp_f11 VDDIO VSS VSS VSS nfet L=0.35U W=2U
Mt14esd_Mclamp_f12 VDDIO VSS VSS VSS nfet L=0.35U W=2U
Mt14esd_Mclamp_f13 VDDIO VSS VSS VSS nfet L=0.35U W=2U
Mt14esd_Mclamp_f14 VDDIO VSS VSS VSS nfet L=0.35U W=2U
Mt14esd_Mclamp_f15 VDDIO VSS VSS VSS nfet L=0.35U W=2U
Mt14esd_Mclamp_f16 VDDIO VSS VSS VSS nfet L=0.35U W=2U
Mt14esd_Mclamp_f17 VDDIO VSS VSS VSS nfet L=0.35U W=2U
Mt14esd_Mclamp_f18 VDDIO VSS VSS VSS nfet L=0.35U W=2U
Mt14esd_Mclamp_f19 VDDIO VSS VSS VSS nfet L=0.35U W=2U
Xt14esd_Resd PAD$4 PADI_T14 VSS rppd r=294.2 L=2U W=2U
Dt14esd_Dp2 PADI_T14 VDDIO dpantenna A=4P P=8U
Mt14esd_Mn2_f0 PADI_T14 VSS VSS VSS nfet L=0.13U W=1U
Mt14tx_Mi1p_f0 t14tx/OEB OE VDDIO VDDIO pfet L=0.13U W=2U
Mt14tx_Mi1n_f0 t14tx/OEB OE VSS VSS nfet L=0.13U W=1U
Mt14tx_Mnd1p_f0 t14tx/GP DIN$14 VDDIO VDDIO pfet L=0.13U W=2U
Mt14tx_Mnd1p_f1 t14tx/GP DIN$14 VDDIO VDDIO pfet L=0.13U W=2U
Mt14tx_Mnd2p_f0 t14tx/GP OE VDDIO VDDIO pfet L=0.13U W=2U
Mt14tx_Mnd2p_f1 t14tx/GP OE VDDIO VDDIO pfet L=0.13U W=2U
Mt14tx_Mnd1n_f0 t14tx/GP DIN$14 t14tx/NA VSS nfet L=0.13U W=2U
Mt14tx_Mnd1n_f1 t14tx/GP DIN$14 t14tx/NA VSS nfet L=0.13U W=2U
Mt14tx_Mnd2n_f0 t14tx/NA OE VSS VSS nfet L=0.13U W=2U
Mt14tx_Mnd2n_f1 t14tx/NA OE VSS VSS nfet L=0.13U W=2U
Mt14tx_Mnr1p_f0 t14tx/NB DIN$14 VDDIO VDDIO pfet L=0.13U W=2U
Mt14tx_Mnr1p_f1 t14tx/NB DIN$14 VDDIO VDDIO pfet L=0.13U W=2U
Mt14tx_Mnr2p_f0 t14tx/GN t14tx/OEB t14tx/NB VDDIO pfet L=0.13U W=2U
Mt14tx_Mnr2p_f1 t14tx/GN t14tx/OEB t14tx/NB VDDIO pfet L=0.13U W=2U
Mt14tx_Mnr1n_f0 t14tx/GN DIN$14 VSS VSS nfet L=0.13U W=1U
Mt14tx_Mnr1n_f1 t14tx/GN DIN$14 VSS VSS nfet L=0.13U W=1U
Mt14tx_Mnr2n_f0 t14tx/GN t14tx/OEB VSS VSS nfet L=0.13U W=1U
Mt14tx_Mnr2n_f1 t14tx/GN t14tx/OEB VSS VSS nfet L=0.13U W=1U
Mt14tx_Mp_f0 PAD$4 t14tx/GP VDDIO VDDIO pfet L=0.13U W=1U
Mt14tx_Mp_f1 PAD$4 t14tx/GP VDDIO VDDIO pfet L=0.13U W=1U
Mt14tx_Mp_f2 PAD$4 t14tx/GP VDDIO VDDIO pfet L=0.13U W=1U
Mt14tx_Mp_f3 PAD$4 t14tx/GP VDDIO VDDIO pfet L=0.13U W=1U
Mt14tx_Mp_f4 PAD$4 t14tx/GP VDDIO VDDIO pfet L=0.13U W=1U
Mt14tx_Mp_f5 PAD$4 t14tx/GP VDDIO VDDIO pfet L=0.13U W=1U
Mt14tx_Mp_f6 PAD$4 t14tx/GP VDDIO VDDIO pfet L=0.13U W=1U
Mt14tx_Mp_f7 PAD$4 t14tx/GP VDDIO VDDIO pfet L=0.13U W=1U
Mt14tx_Mp_f8 PAD$4 t14tx/GP VDDIO VDDIO pfet L=0.13U W=1U
Mt14tx_Mp_f9 PAD$4 t14tx/GP VDDIO VDDIO pfet L=0.13U W=1U
Mt14tx_Mp_f10 PAD$4 t14tx/GP VDDIO VDDIO pfet L=0.13U W=1U
Mt14tx_Mp_f11 PAD$4 t14tx/GP VDDIO VDDIO pfet L=0.13U W=1U
Mt14tx_Mp_f12 PAD$4 t14tx/GP VDDIO VDDIO pfet L=0.13U W=1U
Mt14tx_Mp_f13 PAD$4 t14tx/GP VDDIO VDDIO pfet L=0.13U W=1U
Mt14tx_Mp_f14 PAD$4 t14tx/GP VDDIO VDDIO pfet L=0.13U W=1U
Mt14tx_Mp_f15 PAD$4 t14tx/GP VDDIO VDDIO pfet L=0.13U W=1U
Mt14tx_Mp_f16 PAD$4 t14tx/GP VDDIO VDDIO pfet L=0.13U W=1U
Mt14tx_Mp_f17 PAD$4 t14tx/GP VDDIO VDDIO pfet L=0.13U W=1U
Mt14tx_Mp_f18 PAD$4 t14tx/GP VDDIO VDDIO pfet L=0.13U W=1U
Mt14tx_Mp_f19 PAD$4 t14tx/GP VDDIO VDDIO pfet L=0.13U W=1U
Mt14tx_Mp_f20 PAD$4 t14tx/GP VDDIO VDDIO pfet L=0.13U W=1U
Mt14tx_Mp_f21 PAD$4 t14tx/GP VDDIO VDDIO pfet L=0.13U W=1U
Mt14tx_Mp_f22 PAD$4 t14tx/GP VDDIO VDDIO pfet L=0.13U W=1U
Mt14tx_Mp_f23 PAD$4 t14tx/GP VDDIO VDDIO pfet L=0.13U W=1U
Mt14tx_Mp_f24 PAD$4 t14tx/GP VDDIO VDDIO pfet L=0.13U W=1U
Mt14tx_Mp_f25 PAD$4 t14tx/GP VDDIO VDDIO pfet L=0.13U W=1U
Mt14tx_Mp_f26 PAD$4 t14tx/GP VDDIO VDDIO pfet L=0.13U W=1U
Mt14tx_Mp_f27 PAD$4 t14tx/GP VDDIO VDDIO pfet L=0.13U W=1U
Mt14tx_Mn_f0 PAD$4 t14tx/GN VSS VSS nfet L=0.13U W=1U
Mt14tx_Mn_f1 PAD$4 t14tx/GN VSS VSS nfet L=0.13U W=1U
Mt14tx_Mn_f2 PAD$4 t14tx/GN VSS VSS nfet L=0.13U W=1U
Mt14tx_Mn_f3 PAD$4 t14tx/GN VSS VSS nfet L=0.13U W=1U
Mt14tx_Mn_f4 PAD$4 t14tx/GN VSS VSS nfet L=0.13U W=1U
Mt14tx_Mn_f5 PAD$4 t14tx/GN VSS VSS nfet L=0.13U W=1U
Mt14tx_Mn_f6 PAD$4 t14tx/GN VSS VSS nfet L=0.13U W=1U
Mt14tx_Mn_f7 PAD$4 t14tx/GN VSS VSS nfet L=0.13U W=1U
Mt14tx_Mn_f8 PAD$4 t14tx/GN VSS VSS nfet L=0.13U W=1U
Mt14tx_Mn_f9 PAD$4 t14tx/GN VSS VSS nfet L=0.13U W=1U
Mt14tx_Mn_f10 PAD$4 t14tx/GN VSS VSS nfet L=0.13U W=1U
Mt14tx_Mn_f11 PAD$4 t14tx/GN VSS VSS nfet L=0.13U W=1U
Mt14tx_Mn_f12 PAD$4 t14tx/GN VSS VSS nfet L=0.13U W=1U
Mt14tx_Mn_f13 PAD$4 t14tx/GN VSS VSS nfet L=0.13U W=1U
Mt14tx_Mpu_f0 t14tx/PUX PUN VDDIO VDDIO pfet L=0.13U W=2U
Xt14tx_Rpu t14tx/PUX PAD$4 VSS rppd r=12472.0 L=24U W=0.5U
Mt14tx_Mpd_f0 t14tx/PDX PD VSS VSS nfet L=0.13U W=1U
Xt14tx_Rpd PAD$4 t14tx/PDX VSS rppd r=12472.0 L=24U W=0.5U
Dt15esd_Dp1 PAD$6 VDDIO dpantenna A=100P P=40U
Dt15esd_Dn1 VSS PAD$6 dantenna A=100P P=40U
Mt15esd_Mclamp_f0 VDDIO VSS VSS VSS nfet L=0.35U W=2U
Mt15esd_Mclamp_f1 VDDIO VSS VSS VSS nfet L=0.35U W=2U
Mt15esd_Mclamp_f2 VDDIO VSS VSS VSS nfet L=0.35U W=2U
Mt15esd_Mclamp_f3 VDDIO VSS VSS VSS nfet L=0.35U W=2U
Mt15esd_Mclamp_f4 VDDIO VSS VSS VSS nfet L=0.35U W=2U
Mt15esd_Mclamp_f5 VDDIO VSS VSS VSS nfet L=0.35U W=2U
Mt15esd_Mclamp_f6 VDDIO VSS VSS VSS nfet L=0.35U W=2U
Mt15esd_Mclamp_f7 VDDIO VSS VSS VSS nfet L=0.35U W=2U
Mt15esd_Mclamp_f8 VDDIO VSS VSS VSS nfet L=0.35U W=2U
Mt15esd_Mclamp_f9 VDDIO VSS VSS VSS nfet L=0.35U W=2U
Mt15esd_Mclamp_f10 VDDIO VSS VSS VSS nfet L=0.35U W=2U
Mt15esd_Mclamp_f11 VDDIO VSS VSS VSS nfet L=0.35U W=2U
Mt15esd_Mclamp_f12 VDDIO VSS VSS VSS nfet L=0.35U W=2U
Mt15esd_Mclamp_f13 VDDIO VSS VSS VSS nfet L=0.35U W=2U
Mt15esd_Mclamp_f14 VDDIO VSS VSS VSS nfet L=0.35U W=2U
Mt15esd_Mclamp_f15 VDDIO VSS VSS VSS nfet L=0.35U W=2U
Mt15esd_Mclamp_f16 VDDIO VSS VSS VSS nfet L=0.35U W=2U
Mt15esd_Mclamp_f17 VDDIO VSS VSS VSS nfet L=0.35U W=2U
Mt15esd_Mclamp_f18 VDDIO VSS VSS VSS nfet L=0.35U W=2U
Mt15esd_Mclamp_f19 VDDIO VSS VSS VSS nfet L=0.35U W=2U
Xt15esd_Resd PAD$6 PADI_T15 VSS rppd r=294.2 L=2U W=2U
Dt15esd_Dp2 PADI_T15 VDDIO dpantenna A=4P P=8U
Mt15esd_Mn2_f0 PADI_T15 VSS VSS VSS nfet L=0.13U W=1U
Mt15tx_Mi1p_f0 t15tx/OEB OE VDDIO VDDIO pfet L=0.13U W=2U
Mt15tx_Mi1n_f0 t15tx/OEB OE VSS VSS nfet L=0.13U W=1U
Mt15tx_Mnd1p_f0 t15tx/GP DIN$15 VDDIO VDDIO pfet L=0.13U W=2U
Mt15tx_Mnd1p_f1 t15tx/GP DIN$15 VDDIO VDDIO pfet L=0.13U W=2U
Mt15tx_Mnd2p_f0 t15tx/GP OE VDDIO VDDIO pfet L=0.13U W=2U
Mt15tx_Mnd2p_f1 t15tx/GP OE VDDIO VDDIO pfet L=0.13U W=2U
Mt15tx_Mnd1n_f0 t15tx/GP DIN$15 t15tx/NA VSS nfet L=0.13U W=2U
Mt15tx_Mnd1n_f1 t15tx/GP DIN$15 t15tx/NA VSS nfet L=0.13U W=2U
Mt15tx_Mnd2n_f0 t15tx/NA OE VSS VSS nfet L=0.13U W=2U
Mt15tx_Mnd2n_f1 t15tx/NA OE VSS VSS nfet L=0.13U W=2U
Mt15tx_Mnr1p_f0 t15tx/NB DIN$15 VDDIO VDDIO pfet L=0.13U W=2U
Mt15tx_Mnr1p_f1 t15tx/NB DIN$15 VDDIO VDDIO pfet L=0.13U W=2U
Mt15tx_Mnr2p_f0 t15tx/GN t15tx/OEB t15tx/NB VDDIO pfet L=0.13U W=2U
Mt15tx_Mnr2p_f1 t15tx/GN t15tx/OEB t15tx/NB VDDIO pfet L=0.13U W=2U
Mt15tx_Mnr1n_f0 t15tx/GN DIN$15 VSS VSS nfet L=0.13U W=1U
Mt15tx_Mnr1n_f1 t15tx/GN DIN$15 VSS VSS nfet L=0.13U W=1U
Mt15tx_Mnr2n_f0 t15tx/GN t15tx/OEB VSS VSS nfet L=0.13U W=1U
Mt15tx_Mnr2n_f1 t15tx/GN t15tx/OEB VSS VSS nfet L=0.13U W=1U
Mt15tx_Mp_f0 PAD$6 t15tx/GP VDDIO VDDIO pfet L=0.13U W=1U
Mt15tx_Mp_f1 PAD$6 t15tx/GP VDDIO VDDIO pfet L=0.13U W=1U
Mt15tx_Mp_f2 PAD$6 t15tx/GP VDDIO VDDIO pfet L=0.13U W=1U
Mt15tx_Mp_f3 PAD$6 t15tx/GP VDDIO VDDIO pfet L=0.13U W=1U
Mt15tx_Mp_f4 PAD$6 t15tx/GP VDDIO VDDIO pfet L=0.13U W=1U
Mt15tx_Mp_f5 PAD$6 t15tx/GP VDDIO VDDIO pfet L=0.13U W=1U
Mt15tx_Mp_f6 PAD$6 t15tx/GP VDDIO VDDIO pfet L=0.13U W=1U
Mt15tx_Mp_f7 PAD$6 t15tx/GP VDDIO VDDIO pfet L=0.13U W=1U
Mt15tx_Mp_f8 PAD$6 t15tx/GP VDDIO VDDIO pfet L=0.13U W=1U
Mt15tx_Mp_f9 PAD$6 t15tx/GP VDDIO VDDIO pfet L=0.13U W=1U
Mt15tx_Mp_f10 PAD$6 t15tx/GP VDDIO VDDIO pfet L=0.13U W=1U
Mt15tx_Mp_f11 PAD$6 t15tx/GP VDDIO VDDIO pfet L=0.13U W=1U
Mt15tx_Mp_f12 PAD$6 t15tx/GP VDDIO VDDIO pfet L=0.13U W=1U
Mt15tx_Mp_f13 PAD$6 t15tx/GP VDDIO VDDIO pfet L=0.13U W=1U
Mt15tx_Mp_f14 PAD$6 t15tx/GP VDDIO VDDIO pfet L=0.13U W=1U
Mt15tx_Mp_f15 PAD$6 t15tx/GP VDDIO VDDIO pfet L=0.13U W=1U
Mt15tx_Mp_f16 PAD$6 t15tx/GP VDDIO VDDIO pfet L=0.13U W=1U
Mt15tx_Mp_f17 PAD$6 t15tx/GP VDDIO VDDIO pfet L=0.13U W=1U
Mt15tx_Mp_f18 PAD$6 t15tx/GP VDDIO VDDIO pfet L=0.13U W=1U
Mt15tx_Mp_f19 PAD$6 t15tx/GP VDDIO VDDIO pfet L=0.13U W=1U
Mt15tx_Mp_f20 PAD$6 t15tx/GP VDDIO VDDIO pfet L=0.13U W=1U
Mt15tx_Mp_f21 PAD$6 t15tx/GP VDDIO VDDIO pfet L=0.13U W=1U
Mt15tx_Mp_f22 PAD$6 t15tx/GP VDDIO VDDIO pfet L=0.13U W=1U
Mt15tx_Mp_f23 PAD$6 t15tx/GP VDDIO VDDIO pfet L=0.13U W=1U
Mt15tx_Mp_f24 PAD$6 t15tx/GP VDDIO VDDIO pfet L=0.13U W=1U
Mt15tx_Mp_f25 PAD$6 t15tx/GP VDDIO VDDIO pfet L=0.13U W=1U
Mt15tx_Mp_f26 PAD$6 t15tx/GP VDDIO VDDIO pfet L=0.13U W=1U
Mt15tx_Mp_f27 PAD$6 t15tx/GP VDDIO VDDIO pfet L=0.13U W=1U
Mt15tx_Mn_f0 PAD$6 t15tx/GN VSS VSS nfet L=0.13U W=1U
Mt15tx_Mn_f1 PAD$6 t15tx/GN VSS VSS nfet L=0.13U W=1U
Mt15tx_Mn_f2 PAD$6 t15tx/GN VSS VSS nfet L=0.13U W=1U
Mt15tx_Mn_f3 PAD$6 t15tx/GN VSS VSS nfet L=0.13U W=1U
Mt15tx_Mn_f4 PAD$6 t15tx/GN VSS VSS nfet L=0.13U W=1U
Mt15tx_Mn_f5 PAD$6 t15tx/GN VSS VSS nfet L=0.13U W=1U
Mt15tx_Mn_f6 PAD$6 t15tx/GN VSS VSS nfet L=0.13U W=1U
Mt15tx_Mn_f7 PAD$6 t15tx/GN VSS VSS nfet L=0.13U W=1U
Mt15tx_Mn_f8 PAD$6 t15tx/GN VSS VSS nfet L=0.13U W=1U
Mt15tx_Mn_f9 PAD$6 t15tx/GN VSS VSS nfet L=0.13U W=1U
Mt15tx_Mn_f10 PAD$6 t15tx/GN VSS VSS nfet L=0.13U W=1U
Mt15tx_Mn_f11 PAD$6 t15tx/GN VSS VSS nfet L=0.13U W=1U
Mt15tx_Mn_f12 PAD$6 t15tx/GN VSS VSS nfet L=0.13U W=1U
Mt15tx_Mn_f13 PAD$6 t15tx/GN VSS VSS nfet L=0.13U W=1U
Mt15tx_Mpu_f0 t15tx/PUX PUN VDDIO VDDIO pfet L=0.13U W=2U
Xt15tx_Rpu t15tx/PUX PAD$6 VSS rppd r=12472.0 L=24U W=0.5U
Mt15tx_Mpd_f0 t15tx/PDX PD VSS VSS nfet L=0.13U W=1U
Xt15tx_Rpd PAD$6 t15tx/PDX VSS rppd r=12472.0 L=24U W=0.5U
Dt16esd_Dp1 PAD$8 VDDIO dpantenna A=100P P=40U
Dt16esd_Dn1 VSS PAD$8 dantenna A=100P P=40U
Mt16esd_Mclamp_f0 VDDIO VSS VSS VSS nfet L=0.35U W=2U
Mt16esd_Mclamp_f1 VDDIO VSS VSS VSS nfet L=0.35U W=2U
Mt16esd_Mclamp_f2 VDDIO VSS VSS VSS nfet L=0.35U W=2U
Mt16esd_Mclamp_f3 VDDIO VSS VSS VSS nfet L=0.35U W=2U
Mt16esd_Mclamp_f4 VDDIO VSS VSS VSS nfet L=0.35U W=2U
Mt16esd_Mclamp_f5 VDDIO VSS VSS VSS nfet L=0.35U W=2U
Mt16esd_Mclamp_f6 VDDIO VSS VSS VSS nfet L=0.35U W=2U
Mt16esd_Mclamp_f7 VDDIO VSS VSS VSS nfet L=0.35U W=2U
Mt16esd_Mclamp_f8 VDDIO VSS VSS VSS nfet L=0.35U W=2U
Mt16esd_Mclamp_f9 VDDIO VSS VSS VSS nfet L=0.35U W=2U
Mt16esd_Mclamp_f10 VDDIO VSS VSS VSS nfet L=0.35U W=2U
Mt16esd_Mclamp_f11 VDDIO VSS VSS VSS nfet L=0.35U W=2U
Mt16esd_Mclamp_f12 VDDIO VSS VSS VSS nfet L=0.35U W=2U
Mt16esd_Mclamp_f13 VDDIO VSS VSS VSS nfet L=0.35U W=2U
Mt16esd_Mclamp_f14 VDDIO VSS VSS VSS nfet L=0.35U W=2U
Mt16esd_Mclamp_f15 VDDIO VSS VSS VSS nfet L=0.35U W=2U
Mt16esd_Mclamp_f16 VDDIO VSS VSS VSS nfet L=0.35U W=2U
Mt16esd_Mclamp_f17 VDDIO VSS VSS VSS nfet L=0.35U W=2U
Mt16esd_Mclamp_f18 VDDIO VSS VSS VSS nfet L=0.35U W=2U
Mt16esd_Mclamp_f19 VDDIO VSS VSS VSS nfet L=0.35U W=2U
Xt16esd_Resd PAD$8 PADI_T16 VSS rppd r=294.2 L=2U W=2U
Dt16esd_Dp2 PADI_T16 VDDIO dpantenna A=4P P=8U
Mt16esd_Mn2_f0 PADI_T16 VSS VSS VSS nfet L=0.13U W=1U
Mt16tx_Mi1p_f0 t16tx/OEB OE VDDIO VDDIO pfet L=0.13U W=2U
Mt16tx_Mi1n_f0 t16tx/OEB OE VSS VSS nfet L=0.13U W=1U
Mt16tx_Mnd1p_f0 t16tx/GP DIN$16 VDDIO VDDIO pfet L=0.13U W=2U
Mt16tx_Mnd1p_f1 t16tx/GP DIN$16 VDDIO VDDIO pfet L=0.13U W=2U
Mt16tx_Mnd2p_f0 t16tx/GP OE VDDIO VDDIO pfet L=0.13U W=2U
Mt16tx_Mnd2p_f1 t16tx/GP OE VDDIO VDDIO pfet L=0.13U W=2U
Mt16tx_Mnd1n_f0 t16tx/GP DIN$16 t16tx/NA VSS nfet L=0.13U W=2U
Mt16tx_Mnd1n_f1 t16tx/GP DIN$16 t16tx/NA VSS nfet L=0.13U W=2U
Mt16tx_Mnd2n_f0 t16tx/NA OE VSS VSS nfet L=0.13U W=2U
Mt16tx_Mnd2n_f1 t16tx/NA OE VSS VSS nfet L=0.13U W=2U
Mt16tx_Mnr1p_f0 t16tx/NB DIN$16 VDDIO VDDIO pfet L=0.13U W=2U
Mt16tx_Mnr1p_f1 t16tx/NB DIN$16 VDDIO VDDIO pfet L=0.13U W=2U
Mt16tx_Mnr2p_f0 t16tx/GN t16tx/OEB t16tx/NB VDDIO pfet L=0.13U W=2U
Mt16tx_Mnr2p_f1 t16tx/GN t16tx/OEB t16tx/NB VDDIO pfet L=0.13U W=2U
Mt16tx_Mnr1n_f0 t16tx/GN DIN$16 VSS VSS nfet L=0.13U W=1U
Mt16tx_Mnr1n_f1 t16tx/GN DIN$16 VSS VSS nfet L=0.13U W=1U
Mt16tx_Mnr2n_f0 t16tx/GN t16tx/OEB VSS VSS nfet L=0.13U W=1U
Mt16tx_Mnr2n_f1 t16tx/GN t16tx/OEB VSS VSS nfet L=0.13U W=1U
Mt16tx_Mp_f0 PAD$8 t16tx/GP VDDIO VDDIO pfet L=0.13U W=1U
Mt16tx_Mp_f1 PAD$8 t16tx/GP VDDIO VDDIO pfet L=0.13U W=1U
Mt16tx_Mp_f2 PAD$8 t16tx/GP VDDIO VDDIO pfet L=0.13U W=1U
Mt16tx_Mp_f3 PAD$8 t16tx/GP VDDIO VDDIO pfet L=0.13U W=1U
Mt16tx_Mp_f4 PAD$8 t16tx/GP VDDIO VDDIO pfet L=0.13U W=1U
Mt16tx_Mp_f5 PAD$8 t16tx/GP VDDIO VDDIO pfet L=0.13U W=1U
Mt16tx_Mp_f6 PAD$8 t16tx/GP VDDIO VDDIO pfet L=0.13U W=1U
Mt16tx_Mp_f7 PAD$8 t16tx/GP VDDIO VDDIO pfet L=0.13U W=1U
Mt16tx_Mp_f8 PAD$8 t16tx/GP VDDIO VDDIO pfet L=0.13U W=1U
Mt16tx_Mp_f9 PAD$8 t16tx/GP VDDIO VDDIO pfet L=0.13U W=1U
Mt16tx_Mp_f10 PAD$8 t16tx/GP VDDIO VDDIO pfet L=0.13U W=1U
Mt16tx_Mp_f11 PAD$8 t16tx/GP VDDIO VDDIO pfet L=0.13U W=1U
Mt16tx_Mp_f12 PAD$8 t16tx/GP VDDIO VDDIO pfet L=0.13U W=1U
Mt16tx_Mp_f13 PAD$8 t16tx/GP VDDIO VDDIO pfet L=0.13U W=1U
Mt16tx_Mp_f14 PAD$8 t16tx/GP VDDIO VDDIO pfet L=0.13U W=1U
Mt16tx_Mp_f15 PAD$8 t16tx/GP VDDIO VDDIO pfet L=0.13U W=1U
Mt16tx_Mp_f16 PAD$8 t16tx/GP VDDIO VDDIO pfet L=0.13U W=1U
Mt16tx_Mp_f17 PAD$8 t16tx/GP VDDIO VDDIO pfet L=0.13U W=1U
Mt16tx_Mp_f18 PAD$8 t16tx/GP VDDIO VDDIO pfet L=0.13U W=1U
Mt16tx_Mp_f19 PAD$8 t16tx/GP VDDIO VDDIO pfet L=0.13U W=1U
Mt16tx_Mp_f20 PAD$8 t16tx/GP VDDIO VDDIO pfet L=0.13U W=1U
Mt16tx_Mp_f21 PAD$8 t16tx/GP VDDIO VDDIO pfet L=0.13U W=1U
Mt16tx_Mp_f22 PAD$8 t16tx/GP VDDIO VDDIO pfet L=0.13U W=1U
Mt16tx_Mp_f23 PAD$8 t16tx/GP VDDIO VDDIO pfet L=0.13U W=1U
Mt16tx_Mp_f24 PAD$8 t16tx/GP VDDIO VDDIO pfet L=0.13U W=1U
Mt16tx_Mp_f25 PAD$8 t16tx/GP VDDIO VDDIO pfet L=0.13U W=1U
Mt16tx_Mp_f26 PAD$8 t16tx/GP VDDIO VDDIO pfet L=0.13U W=1U
Mt16tx_Mp_f27 PAD$8 t16tx/GP VDDIO VDDIO pfet L=0.13U W=1U
Mt16tx_Mn_f0 PAD$8 t16tx/GN VSS VSS nfet L=0.13U W=1U
Mt16tx_Mn_f1 PAD$8 t16tx/GN VSS VSS nfet L=0.13U W=1U
Mt16tx_Mn_f2 PAD$8 t16tx/GN VSS VSS nfet L=0.13U W=1U
Mt16tx_Mn_f3 PAD$8 t16tx/GN VSS VSS nfet L=0.13U W=1U
Mt16tx_Mn_f4 PAD$8 t16tx/GN VSS VSS nfet L=0.13U W=1U
Mt16tx_Mn_f5 PAD$8 t16tx/GN VSS VSS nfet L=0.13U W=1U
Mt16tx_Mn_f6 PAD$8 t16tx/GN VSS VSS nfet L=0.13U W=1U
Mt16tx_Mn_f7 PAD$8 t16tx/GN VSS VSS nfet L=0.13U W=1U
Mt16tx_Mn_f8 PAD$8 t16tx/GN VSS VSS nfet L=0.13U W=1U
Mt16tx_Mn_f9 PAD$8 t16tx/GN VSS VSS nfet L=0.13U W=1U
Mt16tx_Mn_f10 PAD$8 t16tx/GN VSS VSS nfet L=0.13U W=1U
Mt16tx_Mn_f11 PAD$8 t16tx/GN VSS VSS nfet L=0.13U W=1U
Mt16tx_Mn_f12 PAD$8 t16tx/GN VSS VSS nfet L=0.13U W=1U
Mt16tx_Mn_f13 PAD$8 t16tx/GN VSS VSS nfet L=0.13U W=1U
Mt16tx_Mpu_f0 t16tx/PUX PUN VDDIO VDDIO pfet L=0.13U W=2U
Xt16tx_Rpu t16tx/PUX PAD$8 VSS rppd r=12472.0 L=24U W=0.5U
Mt16tx_Mpd_f0 t16tx/PDX PD VSS VSS nfet L=0.13U W=1U
Xt16tx_Rpd PAD$8 t16tx/PDX VSS rppd r=12472.0 L=24U W=0.5U
Dt17esd_Dp1 PAD$10 VDDIO dpantenna A=100P P=40U
Dt17esd_Dn1 VSS PAD$10 dantenna A=100P P=40U
Mt17esd_Mclamp_f0 VDDIO VSS VSS VSS nfet L=0.35U W=2U
Mt17esd_Mclamp_f1 VDDIO VSS VSS VSS nfet L=0.35U W=2U
Mt17esd_Mclamp_f2 VDDIO VSS VSS VSS nfet L=0.35U W=2U
Mt17esd_Mclamp_f3 VDDIO VSS VSS VSS nfet L=0.35U W=2U
Mt17esd_Mclamp_f4 VDDIO VSS VSS VSS nfet L=0.35U W=2U
Mt17esd_Mclamp_f5 VDDIO VSS VSS VSS nfet L=0.35U W=2U
Mt17esd_Mclamp_f6 VDDIO VSS VSS VSS nfet L=0.35U W=2U
Mt17esd_Mclamp_f7 VDDIO VSS VSS VSS nfet L=0.35U W=2U
Mt17esd_Mclamp_f8 VDDIO VSS VSS VSS nfet L=0.35U W=2U
Mt17esd_Mclamp_f9 VDDIO VSS VSS VSS nfet L=0.35U W=2U
Mt17esd_Mclamp_f10 VDDIO VSS VSS VSS nfet L=0.35U W=2U
Mt17esd_Mclamp_f11 VDDIO VSS VSS VSS nfet L=0.35U W=2U
Mt17esd_Mclamp_f12 VDDIO VSS VSS VSS nfet L=0.35U W=2U
Mt17esd_Mclamp_f13 VDDIO VSS VSS VSS nfet L=0.35U W=2U
Mt17esd_Mclamp_f14 VDDIO VSS VSS VSS nfet L=0.35U W=2U
Mt17esd_Mclamp_f15 VDDIO VSS VSS VSS nfet L=0.35U W=2U
Mt17esd_Mclamp_f16 VDDIO VSS VSS VSS nfet L=0.35U W=2U
Mt17esd_Mclamp_f17 VDDIO VSS VSS VSS nfet L=0.35U W=2U
Mt17esd_Mclamp_f18 VDDIO VSS VSS VSS nfet L=0.35U W=2U
Mt17esd_Mclamp_f19 VDDIO VSS VSS VSS nfet L=0.35U W=2U
Xt17esd_Resd PAD$10 PADI_T17 VSS rppd r=294.2 L=2U W=2U
Dt17esd_Dp2 PADI_T17 VDDIO dpantenna A=4P P=8U
Mt17esd_Mn2_f0 PADI_T17 VSS VSS VSS nfet L=0.13U W=1U
Mt17tx_Mi1p_f0 t17tx/OEB OE VDDIO VDDIO pfet L=0.13U W=2U
Mt17tx_Mi1n_f0 t17tx/OEB OE VSS VSS nfet L=0.13U W=1U
Mt17tx_Mnd1p_f0 t17tx/GP DIN$17 VDDIO VDDIO pfet L=0.13U W=2U
Mt17tx_Mnd1p_f1 t17tx/GP DIN$17 VDDIO VDDIO pfet L=0.13U W=2U
Mt17tx_Mnd2p_f0 t17tx/GP OE VDDIO VDDIO pfet L=0.13U W=2U
Mt17tx_Mnd2p_f1 t17tx/GP OE VDDIO VDDIO pfet L=0.13U W=2U
Mt17tx_Mnd1n_f0 t17tx/GP DIN$17 t17tx/NA VSS nfet L=0.13U W=2U
Mt17tx_Mnd1n_f1 t17tx/GP DIN$17 t17tx/NA VSS nfet L=0.13U W=2U
Mt17tx_Mnd2n_f0 t17tx/NA OE VSS VSS nfet L=0.13U W=2U
Mt17tx_Mnd2n_f1 t17tx/NA OE VSS VSS nfet L=0.13U W=2U
Mt17tx_Mnr1p_f0 t17tx/NB DIN$17 VDDIO VDDIO pfet L=0.13U W=2U
Mt17tx_Mnr1p_f1 t17tx/NB DIN$17 VDDIO VDDIO pfet L=0.13U W=2U
Mt17tx_Mnr2p_f0 t17tx/GN t17tx/OEB t17tx/NB VDDIO pfet L=0.13U W=2U
Mt17tx_Mnr2p_f1 t17tx/GN t17tx/OEB t17tx/NB VDDIO pfet L=0.13U W=2U
Mt17tx_Mnr1n_f0 t17tx/GN DIN$17 VSS VSS nfet L=0.13U W=1U
Mt17tx_Mnr1n_f1 t17tx/GN DIN$17 VSS VSS nfet L=0.13U W=1U
Mt17tx_Mnr2n_f0 t17tx/GN t17tx/OEB VSS VSS nfet L=0.13U W=1U
Mt17tx_Mnr2n_f1 t17tx/GN t17tx/OEB VSS VSS nfet L=0.13U W=1U
Mt17tx_Mp_f0 PAD$10 t17tx/GP VDDIO VDDIO pfet L=0.13U W=1U
Mt17tx_Mp_f1 PAD$10 t17tx/GP VDDIO VDDIO pfet L=0.13U W=1U
Mt17tx_Mp_f2 PAD$10 t17tx/GP VDDIO VDDIO pfet L=0.13U W=1U
Mt17tx_Mp_f3 PAD$10 t17tx/GP VDDIO VDDIO pfet L=0.13U W=1U
Mt17tx_Mp_f4 PAD$10 t17tx/GP VDDIO VDDIO pfet L=0.13U W=1U
Mt17tx_Mp_f5 PAD$10 t17tx/GP VDDIO VDDIO pfet L=0.13U W=1U
Mt17tx_Mp_f6 PAD$10 t17tx/GP VDDIO VDDIO pfet L=0.13U W=1U
Mt17tx_Mp_f7 PAD$10 t17tx/GP VDDIO VDDIO pfet L=0.13U W=1U
Mt17tx_Mp_f8 PAD$10 t17tx/GP VDDIO VDDIO pfet L=0.13U W=1U
Mt17tx_Mp_f9 PAD$10 t17tx/GP VDDIO VDDIO pfet L=0.13U W=1U
Mt17tx_Mp_f10 PAD$10 t17tx/GP VDDIO VDDIO pfet L=0.13U W=1U
Mt17tx_Mp_f11 PAD$10 t17tx/GP VDDIO VDDIO pfet L=0.13U W=1U
Mt17tx_Mp_f12 PAD$10 t17tx/GP VDDIO VDDIO pfet L=0.13U W=1U
Mt17tx_Mp_f13 PAD$10 t17tx/GP VDDIO VDDIO pfet L=0.13U W=1U
Mt17tx_Mp_f14 PAD$10 t17tx/GP VDDIO VDDIO pfet L=0.13U W=1U
Mt17tx_Mp_f15 PAD$10 t17tx/GP VDDIO VDDIO pfet L=0.13U W=1U
Mt17tx_Mp_f16 PAD$10 t17tx/GP VDDIO VDDIO pfet L=0.13U W=1U
Mt17tx_Mp_f17 PAD$10 t17tx/GP VDDIO VDDIO pfet L=0.13U W=1U
Mt17tx_Mp_f18 PAD$10 t17tx/GP VDDIO VDDIO pfet L=0.13U W=1U
Mt17tx_Mp_f19 PAD$10 t17tx/GP VDDIO VDDIO pfet L=0.13U W=1U
Mt17tx_Mp_f20 PAD$10 t17tx/GP VDDIO VDDIO pfet L=0.13U W=1U
Mt17tx_Mp_f21 PAD$10 t17tx/GP VDDIO VDDIO pfet L=0.13U W=1U
Mt17tx_Mp_f22 PAD$10 t17tx/GP VDDIO VDDIO pfet L=0.13U W=1U
Mt17tx_Mp_f23 PAD$10 t17tx/GP VDDIO VDDIO pfet L=0.13U W=1U
Mt17tx_Mp_f24 PAD$10 t17tx/GP VDDIO VDDIO pfet L=0.13U W=1U
Mt17tx_Mp_f25 PAD$10 t17tx/GP VDDIO VDDIO pfet L=0.13U W=1U
Mt17tx_Mp_f26 PAD$10 t17tx/GP VDDIO VDDIO pfet L=0.13U W=1U
Mt17tx_Mp_f27 PAD$10 t17tx/GP VDDIO VDDIO pfet L=0.13U W=1U
Mt17tx_Mn_f0 PAD$10 t17tx/GN VSS VSS nfet L=0.13U W=1U
Mt17tx_Mn_f1 PAD$10 t17tx/GN VSS VSS nfet L=0.13U W=1U
Mt17tx_Mn_f2 PAD$10 t17tx/GN VSS VSS nfet L=0.13U W=1U
Mt17tx_Mn_f3 PAD$10 t17tx/GN VSS VSS nfet L=0.13U W=1U
Mt17tx_Mn_f4 PAD$10 t17tx/GN VSS VSS nfet L=0.13U W=1U
Mt17tx_Mn_f5 PAD$10 t17tx/GN VSS VSS nfet L=0.13U W=1U
Mt17tx_Mn_f6 PAD$10 t17tx/GN VSS VSS nfet L=0.13U W=1U
Mt17tx_Mn_f7 PAD$10 t17tx/GN VSS VSS nfet L=0.13U W=1U
Mt17tx_Mn_f8 PAD$10 t17tx/GN VSS VSS nfet L=0.13U W=1U
Mt17tx_Mn_f9 PAD$10 t17tx/GN VSS VSS nfet L=0.13U W=1U
Mt17tx_Mn_f10 PAD$10 t17tx/GN VSS VSS nfet L=0.13U W=1U
Mt17tx_Mn_f11 PAD$10 t17tx/GN VSS VSS nfet L=0.13U W=1U
Mt17tx_Mn_f12 PAD$10 t17tx/GN VSS VSS nfet L=0.13U W=1U
Mt17tx_Mn_f13 PAD$10 t17tx/GN VSS VSS nfet L=0.13U W=1U
Mt17tx_Mpu_f0 t17tx/PUX PUN VDDIO VDDIO pfet L=0.13U W=2U
Xt17tx_Rpu t17tx/PUX PAD$10 VSS rppd r=12472.0 L=24U W=0.5U
Mt17tx_Mpd_f0 t17tx/PDX PD VSS VSS nfet L=0.13U W=1U
Xt17tx_Rpd PAD$10 t17tx/PDX VSS rppd r=12472.0 L=24U W=0.5U
Dt18esd_Dp1 PAD$12 VDDIO dpantenna A=100P P=40U
Dt18esd_Dn1 VSS PAD$12 dantenna A=100P P=40U
Mt18esd_Mclamp_f0 VDDIO VSS VSS VSS nfet L=0.35U W=2U
Mt18esd_Mclamp_f1 VDDIO VSS VSS VSS nfet L=0.35U W=2U
Mt18esd_Mclamp_f2 VDDIO VSS VSS VSS nfet L=0.35U W=2U
Mt18esd_Mclamp_f3 VDDIO VSS VSS VSS nfet L=0.35U W=2U
Mt18esd_Mclamp_f4 VDDIO VSS VSS VSS nfet L=0.35U W=2U
Mt18esd_Mclamp_f5 VDDIO VSS VSS VSS nfet L=0.35U W=2U
Mt18esd_Mclamp_f6 VDDIO VSS VSS VSS nfet L=0.35U W=2U
Mt18esd_Mclamp_f7 VDDIO VSS VSS VSS nfet L=0.35U W=2U
Mt18esd_Mclamp_f8 VDDIO VSS VSS VSS nfet L=0.35U W=2U
Mt18esd_Mclamp_f9 VDDIO VSS VSS VSS nfet L=0.35U W=2U
Mt18esd_Mclamp_f10 VDDIO VSS VSS VSS nfet L=0.35U W=2U
Mt18esd_Mclamp_f11 VDDIO VSS VSS VSS nfet L=0.35U W=2U
Mt18esd_Mclamp_f12 VDDIO VSS VSS VSS nfet L=0.35U W=2U
Mt18esd_Mclamp_f13 VDDIO VSS VSS VSS nfet L=0.35U W=2U
Mt18esd_Mclamp_f14 VDDIO VSS VSS VSS nfet L=0.35U W=2U
Mt18esd_Mclamp_f15 VDDIO VSS VSS VSS nfet L=0.35U W=2U
Mt18esd_Mclamp_f16 VDDIO VSS VSS VSS nfet L=0.35U W=2U
Mt18esd_Mclamp_f17 VDDIO VSS VSS VSS nfet L=0.35U W=2U
Mt18esd_Mclamp_f18 VDDIO VSS VSS VSS nfet L=0.35U W=2U
Mt18esd_Mclamp_f19 VDDIO VSS VSS VSS nfet L=0.35U W=2U
Xt18esd_Resd PAD$12 PADI_T18 VSS rppd r=294.2 L=2U W=2U
Dt18esd_Dp2 PADI_T18 VDDIO dpantenna A=4P P=8U
Mt18esd_Mn2_f0 PADI_T18 VSS VSS VSS nfet L=0.13U W=1U
Mt18tx_Mi1p_f0 t18tx/OEB OE VDDIO VDDIO pfet L=0.13U W=2U
Mt18tx_Mi1n_f0 t18tx/OEB OE VSS VSS nfet L=0.13U W=1U
Mt18tx_Mnd1p_f0 t18tx/GP DIN$18 VDDIO VDDIO pfet L=0.13U W=2U
Mt18tx_Mnd1p_f1 t18tx/GP DIN$18 VDDIO VDDIO pfet L=0.13U W=2U
Mt18tx_Mnd2p_f0 t18tx/GP OE VDDIO VDDIO pfet L=0.13U W=2U
Mt18tx_Mnd2p_f1 t18tx/GP OE VDDIO VDDIO pfet L=0.13U W=2U
Mt18tx_Mnd1n_f0 t18tx/GP DIN$18 t18tx/NA VSS nfet L=0.13U W=2U
Mt18tx_Mnd1n_f1 t18tx/GP DIN$18 t18tx/NA VSS nfet L=0.13U W=2U
Mt18tx_Mnd2n_f0 t18tx/NA OE VSS VSS nfet L=0.13U W=2U
Mt18tx_Mnd2n_f1 t18tx/NA OE VSS VSS nfet L=0.13U W=2U
Mt18tx_Mnr1p_f0 t18tx/NB DIN$18 VDDIO VDDIO pfet L=0.13U W=2U
Mt18tx_Mnr1p_f1 t18tx/NB DIN$18 VDDIO VDDIO pfet L=0.13U W=2U
Mt18tx_Mnr2p_f0 t18tx/GN t18tx/OEB t18tx/NB VDDIO pfet L=0.13U W=2U
Mt18tx_Mnr2p_f1 t18tx/GN t18tx/OEB t18tx/NB VDDIO pfet L=0.13U W=2U
Mt18tx_Mnr1n_f0 t18tx/GN DIN$18 VSS VSS nfet L=0.13U W=1U
Mt18tx_Mnr1n_f1 t18tx/GN DIN$18 VSS VSS nfet L=0.13U W=1U
Mt18tx_Mnr2n_f0 t18tx/GN t18tx/OEB VSS VSS nfet L=0.13U W=1U
Mt18tx_Mnr2n_f1 t18tx/GN t18tx/OEB VSS VSS nfet L=0.13U W=1U
Mt18tx_Mp_f0 PAD$12 t18tx/GP VDDIO VDDIO pfet L=0.13U W=1U
Mt18tx_Mp_f1 PAD$12 t18tx/GP VDDIO VDDIO pfet L=0.13U W=1U
Mt18tx_Mp_f2 PAD$12 t18tx/GP VDDIO VDDIO pfet L=0.13U W=1U
Mt18tx_Mp_f3 PAD$12 t18tx/GP VDDIO VDDIO pfet L=0.13U W=1U
Mt18tx_Mp_f4 PAD$12 t18tx/GP VDDIO VDDIO pfet L=0.13U W=1U
Mt18tx_Mp_f5 PAD$12 t18tx/GP VDDIO VDDIO pfet L=0.13U W=1U
Mt18tx_Mp_f6 PAD$12 t18tx/GP VDDIO VDDIO pfet L=0.13U W=1U
Mt18tx_Mp_f7 PAD$12 t18tx/GP VDDIO VDDIO pfet L=0.13U W=1U
Mt18tx_Mp_f8 PAD$12 t18tx/GP VDDIO VDDIO pfet L=0.13U W=1U
Mt18tx_Mp_f9 PAD$12 t18tx/GP VDDIO VDDIO pfet L=0.13U W=1U
Mt18tx_Mp_f10 PAD$12 t18tx/GP VDDIO VDDIO pfet L=0.13U W=1U
Mt18tx_Mp_f11 PAD$12 t18tx/GP VDDIO VDDIO pfet L=0.13U W=1U
Mt18tx_Mp_f12 PAD$12 t18tx/GP VDDIO VDDIO pfet L=0.13U W=1U
Mt18tx_Mp_f13 PAD$12 t18tx/GP VDDIO VDDIO pfet L=0.13U W=1U
Mt18tx_Mp_f14 PAD$12 t18tx/GP VDDIO VDDIO pfet L=0.13U W=1U
Mt18tx_Mp_f15 PAD$12 t18tx/GP VDDIO VDDIO pfet L=0.13U W=1U
Mt18tx_Mp_f16 PAD$12 t18tx/GP VDDIO VDDIO pfet L=0.13U W=1U
Mt18tx_Mp_f17 PAD$12 t18tx/GP VDDIO VDDIO pfet L=0.13U W=1U
Mt18tx_Mp_f18 PAD$12 t18tx/GP VDDIO VDDIO pfet L=0.13U W=1U
Mt18tx_Mp_f19 PAD$12 t18tx/GP VDDIO VDDIO pfet L=0.13U W=1U
Mt18tx_Mp_f20 PAD$12 t18tx/GP VDDIO VDDIO pfet L=0.13U W=1U
Mt18tx_Mp_f21 PAD$12 t18tx/GP VDDIO VDDIO pfet L=0.13U W=1U
Mt18tx_Mp_f22 PAD$12 t18tx/GP VDDIO VDDIO pfet L=0.13U W=1U
Mt18tx_Mp_f23 PAD$12 t18tx/GP VDDIO VDDIO pfet L=0.13U W=1U
Mt18tx_Mp_f24 PAD$12 t18tx/GP VDDIO VDDIO pfet L=0.13U W=1U
Mt18tx_Mp_f25 PAD$12 t18tx/GP VDDIO VDDIO pfet L=0.13U W=1U
Mt18tx_Mp_f26 PAD$12 t18tx/GP VDDIO VDDIO pfet L=0.13U W=1U
Mt18tx_Mp_f27 PAD$12 t18tx/GP VDDIO VDDIO pfet L=0.13U W=1U
Mt18tx_Mn_f0 PAD$12 t18tx/GN VSS VSS nfet L=0.13U W=1U
Mt18tx_Mn_f1 PAD$12 t18tx/GN VSS VSS nfet L=0.13U W=1U
Mt18tx_Mn_f2 PAD$12 t18tx/GN VSS VSS nfet L=0.13U W=1U
Mt18tx_Mn_f3 PAD$12 t18tx/GN VSS VSS nfet L=0.13U W=1U
Mt18tx_Mn_f4 PAD$12 t18tx/GN VSS VSS nfet L=0.13U W=1U
Mt18tx_Mn_f5 PAD$12 t18tx/GN VSS VSS nfet L=0.13U W=1U
Mt18tx_Mn_f6 PAD$12 t18tx/GN VSS VSS nfet L=0.13U W=1U
Mt18tx_Mn_f7 PAD$12 t18tx/GN VSS VSS nfet L=0.13U W=1U
Mt18tx_Mn_f8 PAD$12 t18tx/GN VSS VSS nfet L=0.13U W=1U
Mt18tx_Mn_f9 PAD$12 t18tx/GN VSS VSS nfet L=0.13U W=1U
Mt18tx_Mn_f10 PAD$12 t18tx/GN VSS VSS nfet L=0.13U W=1U
Mt18tx_Mn_f11 PAD$12 t18tx/GN VSS VSS nfet L=0.13U W=1U
Mt18tx_Mn_f12 PAD$12 t18tx/GN VSS VSS nfet L=0.13U W=1U
Mt18tx_Mn_f13 PAD$12 t18tx/GN VSS VSS nfet L=0.13U W=1U
Mt18tx_Mpu_f0 t18tx/PUX PUN VDDIO VDDIO pfet L=0.13U W=2U
Xt18tx_Rpu t18tx/PUX PAD$12 VSS rppd r=12472.0 L=24U W=0.5U
Mt18tx_Mpd_f0 t18tx/PDX PD VSS VSS nfet L=0.13U W=1U
Xt18tx_Rpd PAD$12 t18tx/PDX VSS rppd r=12472.0 L=24U W=0.5U
Dt19esd_Dp1 PAD$14 VDDIO dpantenna A=100P P=40U
Dt19esd_Dn1 VSS PAD$14 dantenna A=100P P=40U
Mt19esd_Mclamp_f0 VDDIO VSS VSS VSS nfet L=0.35U W=2U
Mt19esd_Mclamp_f1 VDDIO VSS VSS VSS nfet L=0.35U W=2U
Mt19esd_Mclamp_f2 VDDIO VSS VSS VSS nfet L=0.35U W=2U
Mt19esd_Mclamp_f3 VDDIO VSS VSS VSS nfet L=0.35U W=2U
Mt19esd_Mclamp_f4 VDDIO VSS VSS VSS nfet L=0.35U W=2U
Mt19esd_Mclamp_f5 VDDIO VSS VSS VSS nfet L=0.35U W=2U
Mt19esd_Mclamp_f6 VDDIO VSS VSS VSS nfet L=0.35U W=2U
Mt19esd_Mclamp_f7 VDDIO VSS VSS VSS nfet L=0.35U W=2U
Mt19esd_Mclamp_f8 VDDIO VSS VSS VSS nfet L=0.35U W=2U
Mt19esd_Mclamp_f9 VDDIO VSS VSS VSS nfet L=0.35U W=2U
Mt19esd_Mclamp_f10 VDDIO VSS VSS VSS nfet L=0.35U W=2U
Mt19esd_Mclamp_f11 VDDIO VSS VSS VSS nfet L=0.35U W=2U
Mt19esd_Mclamp_f12 VDDIO VSS VSS VSS nfet L=0.35U W=2U
Mt19esd_Mclamp_f13 VDDIO VSS VSS VSS nfet L=0.35U W=2U
Mt19esd_Mclamp_f14 VDDIO VSS VSS VSS nfet L=0.35U W=2U
Mt19esd_Mclamp_f15 VDDIO VSS VSS VSS nfet L=0.35U W=2U
Mt19esd_Mclamp_f16 VDDIO VSS VSS VSS nfet L=0.35U W=2U
Mt19esd_Mclamp_f17 VDDIO VSS VSS VSS nfet L=0.35U W=2U
Mt19esd_Mclamp_f18 VDDIO VSS VSS VSS nfet L=0.35U W=2U
Mt19esd_Mclamp_f19 VDDIO VSS VSS VSS nfet L=0.35U W=2U
Xt19esd_Resd PAD$14 PADI_T19 VSS rppd r=294.2 L=2U W=2U
Dt19esd_Dp2 PADI_T19 VDDIO dpantenna A=4P P=8U
Mt19esd_Mn2_f0 PADI_T19 VSS VSS VSS nfet L=0.13U W=1U
Mt19tx_Mi1p_f0 t19tx/OEB OE VDDIO VDDIO pfet L=0.13U W=2U
Mt19tx_Mi1n_f0 t19tx/OEB OE VSS VSS nfet L=0.13U W=1U
Mt19tx_Mnd1p_f0 t19tx/GP DIN$19 VDDIO VDDIO pfet L=0.13U W=2U
Mt19tx_Mnd1p_f1 t19tx/GP DIN$19 VDDIO VDDIO pfet L=0.13U W=2U
Mt19tx_Mnd2p_f0 t19tx/GP OE VDDIO VDDIO pfet L=0.13U W=2U
Mt19tx_Mnd2p_f1 t19tx/GP OE VDDIO VDDIO pfet L=0.13U W=2U
Mt19tx_Mnd1n_f0 t19tx/GP DIN$19 t19tx/NA VSS nfet L=0.13U W=2U
Mt19tx_Mnd1n_f1 t19tx/GP DIN$19 t19tx/NA VSS nfet L=0.13U W=2U
Mt19tx_Mnd2n_f0 t19tx/NA OE VSS VSS nfet L=0.13U W=2U
Mt19tx_Mnd2n_f1 t19tx/NA OE VSS VSS nfet L=0.13U W=2U
Mt19tx_Mnr1p_f0 t19tx/NB DIN$19 VDDIO VDDIO pfet L=0.13U W=2U
Mt19tx_Mnr1p_f1 t19tx/NB DIN$19 VDDIO VDDIO pfet L=0.13U W=2U
Mt19tx_Mnr2p_f0 t19tx/GN t19tx/OEB t19tx/NB VDDIO pfet L=0.13U W=2U
Mt19tx_Mnr2p_f1 t19tx/GN t19tx/OEB t19tx/NB VDDIO pfet L=0.13U W=2U
Mt19tx_Mnr1n_f0 t19tx/GN DIN$19 VSS VSS nfet L=0.13U W=1U
Mt19tx_Mnr1n_f1 t19tx/GN DIN$19 VSS VSS nfet L=0.13U W=1U
Mt19tx_Mnr2n_f0 t19tx/GN t19tx/OEB VSS VSS nfet L=0.13U W=1U
Mt19tx_Mnr2n_f1 t19tx/GN t19tx/OEB VSS VSS nfet L=0.13U W=1U
Mt19tx_Mp_f0 PAD$14 t19tx/GP VDDIO VDDIO pfet L=0.13U W=1U
Mt19tx_Mp_f1 PAD$14 t19tx/GP VDDIO VDDIO pfet L=0.13U W=1U
Mt19tx_Mp_f2 PAD$14 t19tx/GP VDDIO VDDIO pfet L=0.13U W=1U
Mt19tx_Mp_f3 PAD$14 t19tx/GP VDDIO VDDIO pfet L=0.13U W=1U
Mt19tx_Mp_f4 PAD$14 t19tx/GP VDDIO VDDIO pfet L=0.13U W=1U
Mt19tx_Mp_f5 PAD$14 t19tx/GP VDDIO VDDIO pfet L=0.13U W=1U
Mt19tx_Mp_f6 PAD$14 t19tx/GP VDDIO VDDIO pfet L=0.13U W=1U
Mt19tx_Mp_f7 PAD$14 t19tx/GP VDDIO VDDIO pfet L=0.13U W=1U
Mt19tx_Mp_f8 PAD$14 t19tx/GP VDDIO VDDIO pfet L=0.13U W=1U
Mt19tx_Mp_f9 PAD$14 t19tx/GP VDDIO VDDIO pfet L=0.13U W=1U
Mt19tx_Mp_f10 PAD$14 t19tx/GP VDDIO VDDIO pfet L=0.13U W=1U
Mt19tx_Mp_f11 PAD$14 t19tx/GP VDDIO VDDIO pfet L=0.13U W=1U
Mt19tx_Mp_f12 PAD$14 t19tx/GP VDDIO VDDIO pfet L=0.13U W=1U
Mt19tx_Mp_f13 PAD$14 t19tx/GP VDDIO VDDIO pfet L=0.13U W=1U
Mt19tx_Mp_f14 PAD$14 t19tx/GP VDDIO VDDIO pfet L=0.13U W=1U
Mt19tx_Mp_f15 PAD$14 t19tx/GP VDDIO VDDIO pfet L=0.13U W=1U
Mt19tx_Mp_f16 PAD$14 t19tx/GP VDDIO VDDIO pfet L=0.13U W=1U
Mt19tx_Mp_f17 PAD$14 t19tx/GP VDDIO VDDIO pfet L=0.13U W=1U
Mt19tx_Mp_f18 PAD$14 t19tx/GP VDDIO VDDIO pfet L=0.13U W=1U
Mt19tx_Mp_f19 PAD$14 t19tx/GP VDDIO VDDIO pfet L=0.13U W=1U
Mt19tx_Mp_f20 PAD$14 t19tx/GP VDDIO VDDIO pfet L=0.13U W=1U
Mt19tx_Mp_f21 PAD$14 t19tx/GP VDDIO VDDIO pfet L=0.13U W=1U
Mt19tx_Mp_f22 PAD$14 t19tx/GP VDDIO VDDIO pfet L=0.13U W=1U
Mt19tx_Mp_f23 PAD$14 t19tx/GP VDDIO VDDIO pfet L=0.13U W=1U
Mt19tx_Mp_f24 PAD$14 t19tx/GP VDDIO VDDIO pfet L=0.13U W=1U
Mt19tx_Mp_f25 PAD$14 t19tx/GP VDDIO VDDIO pfet L=0.13U W=1U
Mt19tx_Mp_f26 PAD$14 t19tx/GP VDDIO VDDIO pfet L=0.13U W=1U
Mt19tx_Mp_f27 PAD$14 t19tx/GP VDDIO VDDIO pfet L=0.13U W=1U
Mt19tx_Mn_f0 PAD$14 t19tx/GN VSS VSS nfet L=0.13U W=1U
Mt19tx_Mn_f1 PAD$14 t19tx/GN VSS VSS nfet L=0.13U W=1U
Mt19tx_Mn_f2 PAD$14 t19tx/GN VSS VSS nfet L=0.13U W=1U
Mt19tx_Mn_f3 PAD$14 t19tx/GN VSS VSS nfet L=0.13U W=1U
Mt19tx_Mn_f4 PAD$14 t19tx/GN VSS VSS nfet L=0.13U W=1U
Mt19tx_Mn_f5 PAD$14 t19tx/GN VSS VSS nfet L=0.13U W=1U
Mt19tx_Mn_f6 PAD$14 t19tx/GN VSS VSS nfet L=0.13U W=1U
Mt19tx_Mn_f7 PAD$14 t19tx/GN VSS VSS nfet L=0.13U W=1U
Mt19tx_Mn_f8 PAD$14 t19tx/GN VSS VSS nfet L=0.13U W=1U
Mt19tx_Mn_f9 PAD$14 t19tx/GN VSS VSS nfet L=0.13U W=1U
Mt19tx_Mn_f10 PAD$14 t19tx/GN VSS VSS nfet L=0.13U W=1U
Mt19tx_Mn_f11 PAD$14 t19tx/GN VSS VSS nfet L=0.13U W=1U
Mt19tx_Mn_f12 PAD$14 t19tx/GN VSS VSS nfet L=0.13U W=1U
Mt19tx_Mn_f13 PAD$14 t19tx/GN VSS VSS nfet L=0.13U W=1U
Mt19tx_Mpu_f0 t19tx/PUX PUN VDDIO VDDIO pfet L=0.13U W=2U
Xt19tx_Rpu t19tx/PUX PAD$14 VSS rppd r=12472.0 L=24U W=0.5U
Mt19tx_Mpd_f0 t19tx/PDX PD VSS VSS nfet L=0.13U W=1U
Xt19tx_Rpd PAD$14 t19tx/PDX VSS rppd r=12472.0 L=24U W=0.5U
Dt20esd_Dp1 PAD$16 VDDIO dpantenna A=100P P=40U
Dt20esd_Dn1 VSS PAD$16 dantenna A=100P P=40U
Mt20esd_Mclamp_f0 VDDIO VSS VSS VSS nfet L=0.35U W=2U
Mt20esd_Mclamp_f1 VDDIO VSS VSS VSS nfet L=0.35U W=2U
Mt20esd_Mclamp_f2 VDDIO VSS VSS VSS nfet L=0.35U W=2U
Mt20esd_Mclamp_f3 VDDIO VSS VSS VSS nfet L=0.35U W=2U
Mt20esd_Mclamp_f4 VDDIO VSS VSS VSS nfet L=0.35U W=2U
Mt20esd_Mclamp_f5 VDDIO VSS VSS VSS nfet L=0.35U W=2U
Mt20esd_Mclamp_f6 VDDIO VSS VSS VSS nfet L=0.35U W=2U
Mt20esd_Mclamp_f7 VDDIO VSS VSS VSS nfet L=0.35U W=2U
Mt20esd_Mclamp_f8 VDDIO VSS VSS VSS nfet L=0.35U W=2U
Mt20esd_Mclamp_f9 VDDIO VSS VSS VSS nfet L=0.35U W=2U
Mt20esd_Mclamp_f10 VDDIO VSS VSS VSS nfet L=0.35U W=2U
Mt20esd_Mclamp_f11 VDDIO VSS VSS VSS nfet L=0.35U W=2U
Mt20esd_Mclamp_f12 VDDIO VSS VSS VSS nfet L=0.35U W=2U
Mt20esd_Mclamp_f13 VDDIO VSS VSS VSS nfet L=0.35U W=2U
Mt20esd_Mclamp_f14 VDDIO VSS VSS VSS nfet L=0.35U W=2U
Mt20esd_Mclamp_f15 VDDIO VSS VSS VSS nfet L=0.35U W=2U
Mt20esd_Mclamp_f16 VDDIO VSS VSS VSS nfet L=0.35U W=2U
Mt20esd_Mclamp_f17 VDDIO VSS VSS VSS nfet L=0.35U W=2U
Mt20esd_Mclamp_f18 VDDIO VSS VSS VSS nfet L=0.35U W=2U
Mt20esd_Mclamp_f19 VDDIO VSS VSS VSS nfet L=0.35U W=2U
Xt20esd_Resd PAD$16 PADI_T20 VSS rppd r=294.2 L=2U W=2U
Dt20esd_Dp2 PADI_T20 VDDIO dpantenna A=4P P=8U
Mt20esd_Mn2_f0 PADI_T20 VSS VSS VSS nfet L=0.13U W=1U
Mt20tx_Mi1p_f0 t20tx/OEB OE VDDIO VDDIO pfet L=0.13U W=2U
Mt20tx_Mi1n_f0 t20tx/OEB OE VSS VSS nfet L=0.13U W=1U
Mt20tx_Mnd1p_f0 t20tx/GP DIN$20 VDDIO VDDIO pfet L=0.13U W=2U
Mt20tx_Mnd1p_f1 t20tx/GP DIN$20 VDDIO VDDIO pfet L=0.13U W=2U
Mt20tx_Mnd2p_f0 t20tx/GP OE VDDIO VDDIO pfet L=0.13U W=2U
Mt20tx_Mnd2p_f1 t20tx/GP OE VDDIO VDDIO pfet L=0.13U W=2U
Mt20tx_Mnd1n_f0 t20tx/GP DIN$20 t20tx/NA VSS nfet L=0.13U W=2U
Mt20tx_Mnd1n_f1 t20tx/GP DIN$20 t20tx/NA VSS nfet L=0.13U W=2U
Mt20tx_Mnd2n_f0 t20tx/NA OE VSS VSS nfet L=0.13U W=2U
Mt20tx_Mnd2n_f1 t20tx/NA OE VSS VSS nfet L=0.13U W=2U
Mt20tx_Mnr1p_f0 t20tx/NB DIN$20 VDDIO VDDIO pfet L=0.13U W=2U
Mt20tx_Mnr1p_f1 t20tx/NB DIN$20 VDDIO VDDIO pfet L=0.13U W=2U
Mt20tx_Mnr2p_f0 t20tx/GN t20tx/OEB t20tx/NB VDDIO pfet L=0.13U W=2U
Mt20tx_Mnr2p_f1 t20tx/GN t20tx/OEB t20tx/NB VDDIO pfet L=0.13U W=2U
Mt20tx_Mnr1n_f0 t20tx/GN DIN$20 VSS VSS nfet L=0.13U W=1U
Mt20tx_Mnr1n_f1 t20tx/GN DIN$20 VSS VSS nfet L=0.13U W=1U
Mt20tx_Mnr2n_f0 t20tx/GN t20tx/OEB VSS VSS nfet L=0.13U W=1U
Mt20tx_Mnr2n_f1 t20tx/GN t20tx/OEB VSS VSS nfet L=0.13U W=1U
Mt20tx_Mp_f0 PAD$16 t20tx/GP VDDIO VDDIO pfet L=0.13U W=1U
Mt20tx_Mp_f1 PAD$16 t20tx/GP VDDIO VDDIO pfet L=0.13U W=1U
Mt20tx_Mp_f2 PAD$16 t20tx/GP VDDIO VDDIO pfet L=0.13U W=1U
Mt20tx_Mp_f3 PAD$16 t20tx/GP VDDIO VDDIO pfet L=0.13U W=1U
Mt20tx_Mp_f4 PAD$16 t20tx/GP VDDIO VDDIO pfet L=0.13U W=1U
Mt20tx_Mp_f5 PAD$16 t20tx/GP VDDIO VDDIO pfet L=0.13U W=1U
Mt20tx_Mp_f6 PAD$16 t20tx/GP VDDIO VDDIO pfet L=0.13U W=1U
Mt20tx_Mp_f7 PAD$16 t20tx/GP VDDIO VDDIO pfet L=0.13U W=1U
Mt20tx_Mp_f8 PAD$16 t20tx/GP VDDIO VDDIO pfet L=0.13U W=1U
Mt20tx_Mp_f9 PAD$16 t20tx/GP VDDIO VDDIO pfet L=0.13U W=1U
Mt20tx_Mp_f10 PAD$16 t20tx/GP VDDIO VDDIO pfet L=0.13U W=1U
Mt20tx_Mp_f11 PAD$16 t20tx/GP VDDIO VDDIO pfet L=0.13U W=1U
Mt20tx_Mp_f12 PAD$16 t20tx/GP VDDIO VDDIO pfet L=0.13U W=1U
Mt20tx_Mp_f13 PAD$16 t20tx/GP VDDIO VDDIO pfet L=0.13U W=1U
Mt20tx_Mp_f14 PAD$16 t20tx/GP VDDIO VDDIO pfet L=0.13U W=1U
Mt20tx_Mp_f15 PAD$16 t20tx/GP VDDIO VDDIO pfet L=0.13U W=1U
Mt20tx_Mp_f16 PAD$16 t20tx/GP VDDIO VDDIO pfet L=0.13U W=1U
Mt20tx_Mp_f17 PAD$16 t20tx/GP VDDIO VDDIO pfet L=0.13U W=1U
Mt20tx_Mp_f18 PAD$16 t20tx/GP VDDIO VDDIO pfet L=0.13U W=1U
Mt20tx_Mp_f19 PAD$16 t20tx/GP VDDIO VDDIO pfet L=0.13U W=1U
Mt20tx_Mp_f20 PAD$16 t20tx/GP VDDIO VDDIO pfet L=0.13U W=1U
Mt20tx_Mp_f21 PAD$16 t20tx/GP VDDIO VDDIO pfet L=0.13U W=1U
Mt20tx_Mp_f22 PAD$16 t20tx/GP VDDIO VDDIO pfet L=0.13U W=1U
Mt20tx_Mp_f23 PAD$16 t20tx/GP VDDIO VDDIO pfet L=0.13U W=1U
Mt20tx_Mp_f24 PAD$16 t20tx/GP VDDIO VDDIO pfet L=0.13U W=1U
Mt20tx_Mp_f25 PAD$16 t20tx/GP VDDIO VDDIO pfet L=0.13U W=1U
Mt20tx_Mp_f26 PAD$16 t20tx/GP VDDIO VDDIO pfet L=0.13U W=1U
Mt20tx_Mp_f27 PAD$16 t20tx/GP VDDIO VDDIO pfet L=0.13U W=1U
Mt20tx_Mn_f0 PAD$16 t20tx/GN VSS VSS nfet L=0.13U W=1U
Mt20tx_Mn_f1 PAD$16 t20tx/GN VSS VSS nfet L=0.13U W=1U
Mt20tx_Mn_f2 PAD$16 t20tx/GN VSS VSS nfet L=0.13U W=1U
Mt20tx_Mn_f3 PAD$16 t20tx/GN VSS VSS nfet L=0.13U W=1U
Mt20tx_Mn_f4 PAD$16 t20tx/GN VSS VSS nfet L=0.13U W=1U
Mt20tx_Mn_f5 PAD$16 t20tx/GN VSS VSS nfet L=0.13U W=1U
Mt20tx_Mn_f6 PAD$16 t20tx/GN VSS VSS nfet L=0.13U W=1U
Mt20tx_Mn_f7 PAD$16 t20tx/GN VSS VSS nfet L=0.13U W=1U
Mt20tx_Mn_f8 PAD$16 t20tx/GN VSS VSS nfet L=0.13U W=1U
Mt20tx_Mn_f9 PAD$16 t20tx/GN VSS VSS nfet L=0.13U W=1U
Mt20tx_Mn_f10 PAD$16 t20tx/GN VSS VSS nfet L=0.13U W=1U
Mt20tx_Mn_f11 PAD$16 t20tx/GN VSS VSS nfet L=0.13U W=1U
Mt20tx_Mn_f12 PAD$16 t20tx/GN VSS VSS nfet L=0.13U W=1U
Mt20tx_Mn_f13 PAD$16 t20tx/GN VSS VSS nfet L=0.13U W=1U
Mt20tx_Mpu_f0 t20tx/PUX PUN VDDIO VDDIO pfet L=0.13U W=2U
Xt20tx_Rpu t20tx/PUX PAD$16 VSS rppd r=12472.0 L=24U W=0.5U
Mt20tx_Mpd_f0 t20tx/PDX PD VSS VSS nfet L=0.13U W=1U
Xt20tx_Rpd PAD$16 t20tx/PDX VSS rppd r=12472.0 L=24U W=0.5U
Dt21esd_Dp1 PAD$18 VDDIO dpantenna A=100P P=40U
Dt21esd_Dn1 VSS PAD$18 dantenna A=100P P=40U
Mt21esd_Mclamp_f0 VDDIO VSS VSS VSS nfet L=0.35U W=2U
Mt21esd_Mclamp_f1 VDDIO VSS VSS VSS nfet L=0.35U W=2U
Mt21esd_Mclamp_f2 VDDIO VSS VSS VSS nfet L=0.35U W=2U
Mt21esd_Mclamp_f3 VDDIO VSS VSS VSS nfet L=0.35U W=2U
Mt21esd_Mclamp_f4 VDDIO VSS VSS VSS nfet L=0.35U W=2U
Mt21esd_Mclamp_f5 VDDIO VSS VSS VSS nfet L=0.35U W=2U
Mt21esd_Mclamp_f6 VDDIO VSS VSS VSS nfet L=0.35U W=2U
Mt21esd_Mclamp_f7 VDDIO VSS VSS VSS nfet L=0.35U W=2U
Mt21esd_Mclamp_f8 VDDIO VSS VSS VSS nfet L=0.35U W=2U
Mt21esd_Mclamp_f9 VDDIO VSS VSS VSS nfet L=0.35U W=2U
Mt21esd_Mclamp_f10 VDDIO VSS VSS VSS nfet L=0.35U W=2U
Mt21esd_Mclamp_f11 VDDIO VSS VSS VSS nfet L=0.35U W=2U
Mt21esd_Mclamp_f12 VDDIO VSS VSS VSS nfet L=0.35U W=2U
Mt21esd_Mclamp_f13 VDDIO VSS VSS VSS nfet L=0.35U W=2U
Mt21esd_Mclamp_f14 VDDIO VSS VSS VSS nfet L=0.35U W=2U
Mt21esd_Mclamp_f15 VDDIO VSS VSS VSS nfet L=0.35U W=2U
Mt21esd_Mclamp_f16 VDDIO VSS VSS VSS nfet L=0.35U W=2U
Mt21esd_Mclamp_f17 VDDIO VSS VSS VSS nfet L=0.35U W=2U
Mt21esd_Mclamp_f18 VDDIO VSS VSS VSS nfet L=0.35U W=2U
Mt21esd_Mclamp_f19 VDDIO VSS VSS VSS nfet L=0.35U W=2U
Xt21esd_Resd PAD$18 PADI_T21 VSS rppd r=294.2 L=2U W=2U
Dt21esd_Dp2 PADI_T21 VDDIO dpantenna A=4P P=8U
Mt21esd_Mn2_f0 PADI_T21 VSS VSS VSS nfet L=0.13U W=1U
Mt21tx_Mi1p_f0 t21tx/OEB OE VDDIO VDDIO pfet L=0.13U W=2U
Mt21tx_Mi1n_f0 t21tx/OEB OE VSS VSS nfet L=0.13U W=1U
Mt21tx_Mnd1p_f0 t21tx/GP DIN$21 VDDIO VDDIO pfet L=0.13U W=2U
Mt21tx_Mnd1p_f1 t21tx/GP DIN$21 VDDIO VDDIO pfet L=0.13U W=2U
Mt21tx_Mnd2p_f0 t21tx/GP OE VDDIO VDDIO pfet L=0.13U W=2U
Mt21tx_Mnd2p_f1 t21tx/GP OE VDDIO VDDIO pfet L=0.13U W=2U
Mt21tx_Mnd1n_f0 t21tx/GP DIN$21 t21tx/NA VSS nfet L=0.13U W=2U
Mt21tx_Mnd1n_f1 t21tx/GP DIN$21 t21tx/NA VSS nfet L=0.13U W=2U
Mt21tx_Mnd2n_f0 t21tx/NA OE VSS VSS nfet L=0.13U W=2U
Mt21tx_Mnd2n_f1 t21tx/NA OE VSS VSS nfet L=0.13U W=2U
Mt21tx_Mnr1p_f0 t21tx/NB DIN$21 VDDIO VDDIO pfet L=0.13U W=2U
Mt21tx_Mnr1p_f1 t21tx/NB DIN$21 VDDIO VDDIO pfet L=0.13U W=2U
Mt21tx_Mnr2p_f0 t21tx/GN t21tx/OEB t21tx/NB VDDIO pfet L=0.13U W=2U
Mt21tx_Mnr2p_f1 t21tx/GN t21tx/OEB t21tx/NB VDDIO pfet L=0.13U W=2U
Mt21tx_Mnr1n_f0 t21tx/GN DIN$21 VSS VSS nfet L=0.13U W=1U
Mt21tx_Mnr1n_f1 t21tx/GN DIN$21 VSS VSS nfet L=0.13U W=1U
Mt21tx_Mnr2n_f0 t21tx/GN t21tx/OEB VSS VSS nfet L=0.13U W=1U
Mt21tx_Mnr2n_f1 t21tx/GN t21tx/OEB VSS VSS nfet L=0.13U W=1U
Mt21tx_Mp_f0 PAD$18 t21tx/GP VDDIO VDDIO pfet L=0.13U W=1U
Mt21tx_Mp_f1 PAD$18 t21tx/GP VDDIO VDDIO pfet L=0.13U W=1U
Mt21tx_Mp_f2 PAD$18 t21tx/GP VDDIO VDDIO pfet L=0.13U W=1U
Mt21tx_Mp_f3 PAD$18 t21tx/GP VDDIO VDDIO pfet L=0.13U W=1U
Mt21tx_Mp_f4 PAD$18 t21tx/GP VDDIO VDDIO pfet L=0.13U W=1U
Mt21tx_Mp_f5 PAD$18 t21tx/GP VDDIO VDDIO pfet L=0.13U W=1U
Mt21tx_Mp_f6 PAD$18 t21tx/GP VDDIO VDDIO pfet L=0.13U W=1U
Mt21tx_Mp_f7 PAD$18 t21tx/GP VDDIO VDDIO pfet L=0.13U W=1U
Mt21tx_Mp_f8 PAD$18 t21tx/GP VDDIO VDDIO pfet L=0.13U W=1U
Mt21tx_Mp_f9 PAD$18 t21tx/GP VDDIO VDDIO pfet L=0.13U W=1U
Mt21tx_Mp_f10 PAD$18 t21tx/GP VDDIO VDDIO pfet L=0.13U W=1U
Mt21tx_Mp_f11 PAD$18 t21tx/GP VDDIO VDDIO pfet L=0.13U W=1U
Mt21tx_Mp_f12 PAD$18 t21tx/GP VDDIO VDDIO pfet L=0.13U W=1U
Mt21tx_Mp_f13 PAD$18 t21tx/GP VDDIO VDDIO pfet L=0.13U W=1U
Mt21tx_Mp_f14 PAD$18 t21tx/GP VDDIO VDDIO pfet L=0.13U W=1U
Mt21tx_Mp_f15 PAD$18 t21tx/GP VDDIO VDDIO pfet L=0.13U W=1U
Mt21tx_Mp_f16 PAD$18 t21tx/GP VDDIO VDDIO pfet L=0.13U W=1U
Mt21tx_Mp_f17 PAD$18 t21tx/GP VDDIO VDDIO pfet L=0.13U W=1U
Mt21tx_Mp_f18 PAD$18 t21tx/GP VDDIO VDDIO pfet L=0.13U W=1U
Mt21tx_Mp_f19 PAD$18 t21tx/GP VDDIO VDDIO pfet L=0.13U W=1U
Mt21tx_Mp_f20 PAD$18 t21tx/GP VDDIO VDDIO pfet L=0.13U W=1U
Mt21tx_Mp_f21 PAD$18 t21tx/GP VDDIO VDDIO pfet L=0.13U W=1U
Mt21tx_Mp_f22 PAD$18 t21tx/GP VDDIO VDDIO pfet L=0.13U W=1U
Mt21tx_Mp_f23 PAD$18 t21tx/GP VDDIO VDDIO pfet L=0.13U W=1U
Mt21tx_Mp_f24 PAD$18 t21tx/GP VDDIO VDDIO pfet L=0.13U W=1U
Mt21tx_Mp_f25 PAD$18 t21tx/GP VDDIO VDDIO pfet L=0.13U W=1U
Mt21tx_Mp_f26 PAD$18 t21tx/GP VDDIO VDDIO pfet L=0.13U W=1U
Mt21tx_Mp_f27 PAD$18 t21tx/GP VDDIO VDDIO pfet L=0.13U W=1U
Mt21tx_Mn_f0 PAD$18 t21tx/GN VSS VSS nfet L=0.13U W=1U
Mt21tx_Mn_f1 PAD$18 t21tx/GN VSS VSS nfet L=0.13U W=1U
Mt21tx_Mn_f2 PAD$18 t21tx/GN VSS VSS nfet L=0.13U W=1U
Mt21tx_Mn_f3 PAD$18 t21tx/GN VSS VSS nfet L=0.13U W=1U
Mt21tx_Mn_f4 PAD$18 t21tx/GN VSS VSS nfet L=0.13U W=1U
Mt21tx_Mn_f5 PAD$18 t21tx/GN VSS VSS nfet L=0.13U W=1U
Mt21tx_Mn_f6 PAD$18 t21tx/GN VSS VSS nfet L=0.13U W=1U
Mt21tx_Mn_f7 PAD$18 t21tx/GN VSS VSS nfet L=0.13U W=1U
Mt21tx_Mn_f8 PAD$18 t21tx/GN VSS VSS nfet L=0.13U W=1U
Mt21tx_Mn_f9 PAD$18 t21tx/GN VSS VSS nfet L=0.13U W=1U
Mt21tx_Mn_f10 PAD$18 t21tx/GN VSS VSS nfet L=0.13U W=1U
Mt21tx_Mn_f11 PAD$18 t21tx/GN VSS VSS nfet L=0.13U W=1U
Mt21tx_Mn_f12 PAD$18 t21tx/GN VSS VSS nfet L=0.13U W=1U
Mt21tx_Mn_f13 PAD$18 t21tx/GN VSS VSS nfet L=0.13U W=1U
Mt21tx_Mpu_f0 t21tx/PUX PUN VDDIO VDDIO pfet L=0.13U W=2U
Xt21tx_Rpu t21tx/PUX PAD$18 VSS rppd r=12472.0 L=24U W=0.5U
Mt21tx_Mpd_f0 t21tx/PDX PD VSS VSS nfet L=0.13U W=1U
Xt21tx_Rpd PAD$18 t21tx/PDX VSS rppd r=12472.0 L=24U W=0.5U
Dt22esd_Dp1 PAD$20 VDDIO dpantenna A=100P P=40U
Dt22esd_Dn1 VSS PAD$20 dantenna A=100P P=40U
Mt22esd_Mclamp_f0 VDDIO VSS VSS VSS nfet L=0.35U W=2U
Mt22esd_Mclamp_f1 VDDIO VSS VSS VSS nfet L=0.35U W=2U
Mt22esd_Mclamp_f2 VDDIO VSS VSS VSS nfet L=0.35U W=2U
Mt22esd_Mclamp_f3 VDDIO VSS VSS VSS nfet L=0.35U W=2U
Mt22esd_Mclamp_f4 VDDIO VSS VSS VSS nfet L=0.35U W=2U
Mt22esd_Mclamp_f5 VDDIO VSS VSS VSS nfet L=0.35U W=2U
Mt22esd_Mclamp_f6 VDDIO VSS VSS VSS nfet L=0.35U W=2U
Mt22esd_Mclamp_f7 VDDIO VSS VSS VSS nfet L=0.35U W=2U
Mt22esd_Mclamp_f8 VDDIO VSS VSS VSS nfet L=0.35U W=2U
Mt22esd_Mclamp_f9 VDDIO VSS VSS VSS nfet L=0.35U W=2U
Mt22esd_Mclamp_f10 VDDIO VSS VSS VSS nfet L=0.35U W=2U
Mt22esd_Mclamp_f11 VDDIO VSS VSS VSS nfet L=0.35U W=2U
Mt22esd_Mclamp_f12 VDDIO VSS VSS VSS nfet L=0.35U W=2U
Mt22esd_Mclamp_f13 VDDIO VSS VSS VSS nfet L=0.35U W=2U
Mt22esd_Mclamp_f14 VDDIO VSS VSS VSS nfet L=0.35U W=2U
Mt22esd_Mclamp_f15 VDDIO VSS VSS VSS nfet L=0.35U W=2U
Mt22esd_Mclamp_f16 VDDIO VSS VSS VSS nfet L=0.35U W=2U
Mt22esd_Mclamp_f17 VDDIO VSS VSS VSS nfet L=0.35U W=2U
Mt22esd_Mclamp_f18 VDDIO VSS VSS VSS nfet L=0.35U W=2U
Mt22esd_Mclamp_f19 VDDIO VSS VSS VSS nfet L=0.35U W=2U
Xt22esd_Resd PAD$20 PADI_T22 VSS rppd r=294.2 L=2U W=2U
Dt22esd_Dp2 PADI_T22 VDDIO dpantenna A=4P P=8U
Mt22esd_Mn2_f0 PADI_T22 VSS VSS VSS nfet L=0.13U W=1U
Mt22tx_Mi1p_f0 t22tx/OEB OE VDDIO VDDIO pfet L=0.13U W=2U
Mt22tx_Mi1n_f0 t22tx/OEB OE VSS VSS nfet L=0.13U W=1U
Mt22tx_Mnd1p_f0 t22tx/GP DIN$22 VDDIO VDDIO pfet L=0.13U W=2U
Mt22tx_Mnd1p_f1 t22tx/GP DIN$22 VDDIO VDDIO pfet L=0.13U W=2U
Mt22tx_Mnd2p_f0 t22tx/GP OE VDDIO VDDIO pfet L=0.13U W=2U
Mt22tx_Mnd2p_f1 t22tx/GP OE VDDIO VDDIO pfet L=0.13U W=2U
Mt22tx_Mnd1n_f0 t22tx/GP DIN$22 t22tx/NA VSS nfet L=0.13U W=2U
Mt22tx_Mnd1n_f1 t22tx/GP DIN$22 t22tx/NA VSS nfet L=0.13U W=2U
Mt22tx_Mnd2n_f0 t22tx/NA OE VSS VSS nfet L=0.13U W=2U
Mt22tx_Mnd2n_f1 t22tx/NA OE VSS VSS nfet L=0.13U W=2U
Mt22tx_Mnr1p_f0 t22tx/NB DIN$22 VDDIO VDDIO pfet L=0.13U W=2U
Mt22tx_Mnr1p_f1 t22tx/NB DIN$22 VDDIO VDDIO pfet L=0.13U W=2U
Mt22tx_Mnr2p_f0 t22tx/GN t22tx/OEB t22tx/NB VDDIO pfet L=0.13U W=2U
Mt22tx_Mnr2p_f1 t22tx/GN t22tx/OEB t22tx/NB VDDIO pfet L=0.13U W=2U
Mt22tx_Mnr1n_f0 t22tx/GN DIN$22 VSS VSS nfet L=0.13U W=1U
Mt22tx_Mnr1n_f1 t22tx/GN DIN$22 VSS VSS nfet L=0.13U W=1U
Mt22tx_Mnr2n_f0 t22tx/GN t22tx/OEB VSS VSS nfet L=0.13U W=1U
Mt22tx_Mnr2n_f1 t22tx/GN t22tx/OEB VSS VSS nfet L=0.13U W=1U
Mt22tx_Mp_f0 PAD$20 t22tx/GP VDDIO VDDIO pfet L=0.13U W=1U
Mt22tx_Mp_f1 PAD$20 t22tx/GP VDDIO VDDIO pfet L=0.13U W=1U
Mt22tx_Mp_f2 PAD$20 t22tx/GP VDDIO VDDIO pfet L=0.13U W=1U
Mt22tx_Mp_f3 PAD$20 t22tx/GP VDDIO VDDIO pfet L=0.13U W=1U
Mt22tx_Mp_f4 PAD$20 t22tx/GP VDDIO VDDIO pfet L=0.13U W=1U
Mt22tx_Mp_f5 PAD$20 t22tx/GP VDDIO VDDIO pfet L=0.13U W=1U
Mt22tx_Mp_f6 PAD$20 t22tx/GP VDDIO VDDIO pfet L=0.13U W=1U
Mt22tx_Mp_f7 PAD$20 t22tx/GP VDDIO VDDIO pfet L=0.13U W=1U
Mt22tx_Mp_f8 PAD$20 t22tx/GP VDDIO VDDIO pfet L=0.13U W=1U
Mt22tx_Mp_f9 PAD$20 t22tx/GP VDDIO VDDIO pfet L=0.13U W=1U
Mt22tx_Mp_f10 PAD$20 t22tx/GP VDDIO VDDIO pfet L=0.13U W=1U
Mt22tx_Mp_f11 PAD$20 t22tx/GP VDDIO VDDIO pfet L=0.13U W=1U
Mt22tx_Mp_f12 PAD$20 t22tx/GP VDDIO VDDIO pfet L=0.13U W=1U
Mt22tx_Mp_f13 PAD$20 t22tx/GP VDDIO VDDIO pfet L=0.13U W=1U
Mt22tx_Mp_f14 PAD$20 t22tx/GP VDDIO VDDIO pfet L=0.13U W=1U
Mt22tx_Mp_f15 PAD$20 t22tx/GP VDDIO VDDIO pfet L=0.13U W=1U
Mt22tx_Mp_f16 PAD$20 t22tx/GP VDDIO VDDIO pfet L=0.13U W=1U
Mt22tx_Mp_f17 PAD$20 t22tx/GP VDDIO VDDIO pfet L=0.13U W=1U
Mt22tx_Mp_f18 PAD$20 t22tx/GP VDDIO VDDIO pfet L=0.13U W=1U
Mt22tx_Mp_f19 PAD$20 t22tx/GP VDDIO VDDIO pfet L=0.13U W=1U
Mt22tx_Mp_f20 PAD$20 t22tx/GP VDDIO VDDIO pfet L=0.13U W=1U
Mt22tx_Mp_f21 PAD$20 t22tx/GP VDDIO VDDIO pfet L=0.13U W=1U
Mt22tx_Mp_f22 PAD$20 t22tx/GP VDDIO VDDIO pfet L=0.13U W=1U
Mt22tx_Mp_f23 PAD$20 t22tx/GP VDDIO VDDIO pfet L=0.13U W=1U
Mt22tx_Mp_f24 PAD$20 t22tx/GP VDDIO VDDIO pfet L=0.13U W=1U
Mt22tx_Mp_f25 PAD$20 t22tx/GP VDDIO VDDIO pfet L=0.13U W=1U
Mt22tx_Mp_f26 PAD$20 t22tx/GP VDDIO VDDIO pfet L=0.13U W=1U
Mt22tx_Mp_f27 PAD$20 t22tx/GP VDDIO VDDIO pfet L=0.13U W=1U
Mt22tx_Mn_f0 PAD$20 t22tx/GN VSS VSS nfet L=0.13U W=1U
Mt22tx_Mn_f1 PAD$20 t22tx/GN VSS VSS nfet L=0.13U W=1U
Mt22tx_Mn_f2 PAD$20 t22tx/GN VSS VSS nfet L=0.13U W=1U
Mt22tx_Mn_f3 PAD$20 t22tx/GN VSS VSS nfet L=0.13U W=1U
Mt22tx_Mn_f4 PAD$20 t22tx/GN VSS VSS nfet L=0.13U W=1U
Mt22tx_Mn_f5 PAD$20 t22tx/GN VSS VSS nfet L=0.13U W=1U
Mt22tx_Mn_f6 PAD$20 t22tx/GN VSS VSS nfet L=0.13U W=1U
Mt22tx_Mn_f7 PAD$20 t22tx/GN VSS VSS nfet L=0.13U W=1U
Mt22tx_Mn_f8 PAD$20 t22tx/GN VSS VSS nfet L=0.13U W=1U
Mt22tx_Mn_f9 PAD$20 t22tx/GN VSS VSS nfet L=0.13U W=1U
Mt22tx_Mn_f10 PAD$20 t22tx/GN VSS VSS nfet L=0.13U W=1U
Mt22tx_Mn_f11 PAD$20 t22tx/GN VSS VSS nfet L=0.13U W=1U
Mt22tx_Mn_f12 PAD$20 t22tx/GN VSS VSS nfet L=0.13U W=1U
Mt22tx_Mn_f13 PAD$20 t22tx/GN VSS VSS nfet L=0.13U W=1U
Mt22tx_Mpu_f0 t22tx/PUX PUN VDDIO VDDIO pfet L=0.13U W=2U
Xt22tx_Rpu t22tx/PUX PAD$20 VSS rppd r=12472.0 L=24U W=0.5U
Mt22tx_Mpd_f0 t22tx/PDX PD VSS VSS nfet L=0.13U W=1U
Xt22tx_Rpd PAD$20 t22tx/PDX VSS rppd r=12472.0 L=24U W=0.5U
Dt23esd_Dp1 PAD$22 VDDIO dpantenna A=100P P=40U
Dt23esd_Dn1 VSS PAD$22 dantenna A=100P P=40U
Mt23esd_Mclamp_f0 VDDIO VSS VSS VSS nfet L=0.35U W=2U
Mt23esd_Mclamp_f1 VDDIO VSS VSS VSS nfet L=0.35U W=2U
Mt23esd_Mclamp_f2 VDDIO VSS VSS VSS nfet L=0.35U W=2U
Mt23esd_Mclamp_f3 VDDIO VSS VSS VSS nfet L=0.35U W=2U
Mt23esd_Mclamp_f4 VDDIO VSS VSS VSS nfet L=0.35U W=2U
Mt23esd_Mclamp_f5 VDDIO VSS VSS VSS nfet L=0.35U W=2U
Mt23esd_Mclamp_f6 VDDIO VSS VSS VSS nfet L=0.35U W=2U
Mt23esd_Mclamp_f7 VDDIO VSS VSS VSS nfet L=0.35U W=2U
Mt23esd_Mclamp_f8 VDDIO VSS VSS VSS nfet L=0.35U W=2U
Mt23esd_Mclamp_f9 VDDIO VSS VSS VSS nfet L=0.35U W=2U
Mt23esd_Mclamp_f10 VDDIO VSS VSS VSS nfet L=0.35U W=2U
Mt23esd_Mclamp_f11 VDDIO VSS VSS VSS nfet L=0.35U W=2U
Mt23esd_Mclamp_f12 VDDIO VSS VSS VSS nfet L=0.35U W=2U
Mt23esd_Mclamp_f13 VDDIO VSS VSS VSS nfet L=0.35U W=2U
Mt23esd_Mclamp_f14 VDDIO VSS VSS VSS nfet L=0.35U W=2U
Mt23esd_Mclamp_f15 VDDIO VSS VSS VSS nfet L=0.35U W=2U
Mt23esd_Mclamp_f16 VDDIO VSS VSS VSS nfet L=0.35U W=2U
Mt23esd_Mclamp_f17 VDDIO VSS VSS VSS nfet L=0.35U W=2U
Mt23esd_Mclamp_f18 VDDIO VSS VSS VSS nfet L=0.35U W=2U
Mt23esd_Mclamp_f19 VDDIO VSS VSS VSS nfet L=0.35U W=2U
Xt23esd_Resd PAD$22 PADI_T23 VSS rppd r=294.2 L=2U W=2U
Dt23esd_Dp2 PADI_T23 VDDIO dpantenna A=4P P=8U
Mt23esd_Mn2_f0 PADI_T23 VSS VSS VSS nfet L=0.13U W=1U
Mt23tx_Mi1p_f0 t23tx/OEB OE VDDIO VDDIO pfet L=0.13U W=2U
Mt23tx_Mi1n_f0 t23tx/OEB OE VSS VSS nfet L=0.13U W=1U
Mt23tx_Mnd1p_f0 t23tx/GP DIN$23 VDDIO VDDIO pfet L=0.13U W=2U
Mt23tx_Mnd1p_f1 t23tx/GP DIN$23 VDDIO VDDIO pfet L=0.13U W=2U
Mt23tx_Mnd2p_f0 t23tx/GP OE VDDIO VDDIO pfet L=0.13U W=2U
Mt23tx_Mnd2p_f1 t23tx/GP OE VDDIO VDDIO pfet L=0.13U W=2U
Mt23tx_Mnd1n_f0 t23tx/GP DIN$23 t23tx/NA VSS nfet L=0.13U W=2U
Mt23tx_Mnd1n_f1 t23tx/GP DIN$23 t23tx/NA VSS nfet L=0.13U W=2U
Mt23tx_Mnd2n_f0 t23tx/NA OE VSS VSS nfet L=0.13U W=2U
Mt23tx_Mnd2n_f1 t23tx/NA OE VSS VSS nfet L=0.13U W=2U
Mt23tx_Mnr1p_f0 t23tx/NB DIN$23 VDDIO VDDIO pfet L=0.13U W=2U
Mt23tx_Mnr1p_f1 t23tx/NB DIN$23 VDDIO VDDIO pfet L=0.13U W=2U
Mt23tx_Mnr2p_f0 t23tx/GN t23tx/OEB t23tx/NB VDDIO pfet L=0.13U W=2U
Mt23tx_Mnr2p_f1 t23tx/GN t23tx/OEB t23tx/NB VDDIO pfet L=0.13U W=2U
Mt23tx_Mnr1n_f0 t23tx/GN DIN$23 VSS VSS nfet L=0.13U W=1U
Mt23tx_Mnr1n_f1 t23tx/GN DIN$23 VSS VSS nfet L=0.13U W=1U
Mt23tx_Mnr2n_f0 t23tx/GN t23tx/OEB VSS VSS nfet L=0.13U W=1U
Mt23tx_Mnr2n_f1 t23tx/GN t23tx/OEB VSS VSS nfet L=0.13U W=1U
Mt23tx_Mp_f0 PAD$22 t23tx/GP VDDIO VDDIO pfet L=0.13U W=1U
Mt23tx_Mp_f1 PAD$22 t23tx/GP VDDIO VDDIO pfet L=0.13U W=1U
Mt23tx_Mp_f2 PAD$22 t23tx/GP VDDIO VDDIO pfet L=0.13U W=1U
Mt23tx_Mp_f3 PAD$22 t23tx/GP VDDIO VDDIO pfet L=0.13U W=1U
Mt23tx_Mp_f4 PAD$22 t23tx/GP VDDIO VDDIO pfet L=0.13U W=1U
Mt23tx_Mp_f5 PAD$22 t23tx/GP VDDIO VDDIO pfet L=0.13U W=1U
Mt23tx_Mp_f6 PAD$22 t23tx/GP VDDIO VDDIO pfet L=0.13U W=1U
Mt23tx_Mp_f7 PAD$22 t23tx/GP VDDIO VDDIO pfet L=0.13U W=1U
Mt23tx_Mp_f8 PAD$22 t23tx/GP VDDIO VDDIO pfet L=0.13U W=1U
Mt23tx_Mp_f9 PAD$22 t23tx/GP VDDIO VDDIO pfet L=0.13U W=1U
Mt23tx_Mp_f10 PAD$22 t23tx/GP VDDIO VDDIO pfet L=0.13U W=1U
Mt23tx_Mp_f11 PAD$22 t23tx/GP VDDIO VDDIO pfet L=0.13U W=1U
Mt23tx_Mp_f12 PAD$22 t23tx/GP VDDIO VDDIO pfet L=0.13U W=1U
Mt23tx_Mp_f13 PAD$22 t23tx/GP VDDIO VDDIO pfet L=0.13U W=1U
Mt23tx_Mp_f14 PAD$22 t23tx/GP VDDIO VDDIO pfet L=0.13U W=1U
Mt23tx_Mp_f15 PAD$22 t23tx/GP VDDIO VDDIO pfet L=0.13U W=1U
Mt23tx_Mp_f16 PAD$22 t23tx/GP VDDIO VDDIO pfet L=0.13U W=1U
Mt23tx_Mp_f17 PAD$22 t23tx/GP VDDIO VDDIO pfet L=0.13U W=1U
Mt23tx_Mp_f18 PAD$22 t23tx/GP VDDIO VDDIO pfet L=0.13U W=1U
Mt23tx_Mp_f19 PAD$22 t23tx/GP VDDIO VDDIO pfet L=0.13U W=1U
Mt23tx_Mp_f20 PAD$22 t23tx/GP VDDIO VDDIO pfet L=0.13U W=1U
Mt23tx_Mp_f21 PAD$22 t23tx/GP VDDIO VDDIO pfet L=0.13U W=1U
Mt23tx_Mp_f22 PAD$22 t23tx/GP VDDIO VDDIO pfet L=0.13U W=1U
Mt23tx_Mp_f23 PAD$22 t23tx/GP VDDIO VDDIO pfet L=0.13U W=1U
Mt23tx_Mp_f24 PAD$22 t23tx/GP VDDIO VDDIO pfet L=0.13U W=1U
Mt23tx_Mp_f25 PAD$22 t23tx/GP VDDIO VDDIO pfet L=0.13U W=1U
Mt23tx_Mp_f26 PAD$22 t23tx/GP VDDIO VDDIO pfet L=0.13U W=1U
Mt23tx_Mp_f27 PAD$22 t23tx/GP VDDIO VDDIO pfet L=0.13U W=1U
Mt23tx_Mn_f0 PAD$22 t23tx/GN VSS VSS nfet L=0.13U W=1U
Mt23tx_Mn_f1 PAD$22 t23tx/GN VSS VSS nfet L=0.13U W=1U
Mt23tx_Mn_f2 PAD$22 t23tx/GN VSS VSS nfet L=0.13U W=1U
Mt23tx_Mn_f3 PAD$22 t23tx/GN VSS VSS nfet L=0.13U W=1U
Mt23tx_Mn_f4 PAD$22 t23tx/GN VSS VSS nfet L=0.13U W=1U
Mt23tx_Mn_f5 PAD$22 t23tx/GN VSS VSS nfet L=0.13U W=1U
Mt23tx_Mn_f6 PAD$22 t23tx/GN VSS VSS nfet L=0.13U W=1U
Mt23tx_Mn_f7 PAD$22 t23tx/GN VSS VSS nfet L=0.13U W=1U
Mt23tx_Mn_f8 PAD$22 t23tx/GN VSS VSS nfet L=0.13U W=1U
Mt23tx_Mn_f9 PAD$22 t23tx/GN VSS VSS nfet L=0.13U W=1U
Mt23tx_Mn_f10 PAD$22 t23tx/GN VSS VSS nfet L=0.13U W=1U
Mt23tx_Mn_f11 PAD$22 t23tx/GN VSS VSS nfet L=0.13U W=1U
Mt23tx_Mn_f12 PAD$22 t23tx/GN VSS VSS nfet L=0.13U W=1U
Mt23tx_Mn_f13 PAD$22 t23tx/GN VSS VSS nfet L=0.13U W=1U
Mt23tx_Mpu_f0 t23tx/PUX PUN VDDIO VDDIO pfet L=0.13U W=2U
Xt23tx_Rpu t23tx/PUX PAD$22 VSS rppd r=12472.0 L=24U W=0.5U
Mt23tx_Mpd_f0 t23tx/PDX PD VSS VSS nfet L=0.13U W=1U
Xt23tx_Rpd PAD$22 t23tx/PDX VSS rppd r=12472.0 L=24U W=0.5U
Dr0esd_Dp1 PAD$24 VDDIO dpantenna A=100P P=40U
Dr0esd_Dn1 VSS PAD$24 dantenna A=100P P=40U
Mr0esd_Mclamp_f0 VDDIO VSS VSS VSS nfet L=0.35U W=2U
Mr0esd_Mclamp_f1 VDDIO VSS VSS VSS nfet L=0.35U W=2U
Mr0esd_Mclamp_f2 VDDIO VSS VSS VSS nfet L=0.35U W=2U
Mr0esd_Mclamp_f3 VDDIO VSS VSS VSS nfet L=0.35U W=2U
Mr0esd_Mclamp_f4 VDDIO VSS VSS VSS nfet L=0.35U W=2U
Mr0esd_Mclamp_f5 VDDIO VSS VSS VSS nfet L=0.35U W=2U
Mr0esd_Mclamp_f6 VDDIO VSS VSS VSS nfet L=0.35U W=2U
Mr0esd_Mclamp_f7 VDDIO VSS VSS VSS nfet L=0.35U W=2U
Mr0esd_Mclamp_f8 VDDIO VSS VSS VSS nfet L=0.35U W=2U
Mr0esd_Mclamp_f9 VDDIO VSS VSS VSS nfet L=0.35U W=2U
Mr0esd_Mclamp_f10 VDDIO VSS VSS VSS nfet L=0.35U W=2U
Mr0esd_Mclamp_f11 VDDIO VSS VSS VSS nfet L=0.35U W=2U
Mr0esd_Mclamp_f12 VDDIO VSS VSS VSS nfet L=0.35U W=2U
Mr0esd_Mclamp_f13 VDDIO VSS VSS VSS nfet L=0.35U W=2U
Mr0esd_Mclamp_f14 VDDIO VSS VSS VSS nfet L=0.35U W=2U
Mr0esd_Mclamp_f15 VDDIO VSS VSS VSS nfet L=0.35U W=2U
Mr0esd_Mclamp_f16 VDDIO VSS VSS VSS nfet L=0.35U W=2U
Mr0esd_Mclamp_f17 VDDIO VSS VSS VSS nfet L=0.35U W=2U
Mr0esd_Mclamp_f18 VDDIO VSS VSS VSS nfet L=0.35U W=2U
Mr0esd_Mclamp_f19 VDDIO VSS VSS VSS nfet L=0.35U W=2U
Xr0esd_Resd PAD$24 PADI_R0 VSS rppd r=294.2 L=2U W=2U
Dr0esd_Dp2 PADI_R0 VDDIO dpantenna A=4P P=8U
Mr0esd_Mn2_f0 PADI_R0 VSS VSS VSS nfet L=0.13U W=1U
Mr0rx_Mi1p_f0 r0rx/M1 PADI_R0 VDDIO VDDIO pfet L=0.13U W=1.25U
Mr0rx_Mi1p_f1 r0rx/M1 PADI_R0 VDDIO VDDIO pfet L=0.13U W=1.25U
Mr0rx_Mi1n_f0 r0rx/M1 PADI_R0 VSS VSS nfet L=0.13U W=0.5U
Mr0rx_Mi1n_f1 r0rx/M1 PADI_R0 VSS VSS nfet L=0.13U W=0.5U
Mr0rx_Mi2p_f0 DOUT r0rx/M1 VDDIO VDDIO pfet L=0.13U W=2U
Mr0rx_Mi2p_f1 DOUT r0rx/M1 VDDIO VDDIO pfet L=0.13U W=2U
Mr0rx_Mi2n_f0 DOUT r0rx/M1 VSS VSS nfet L=0.13U W=1U
Mr0rx_Mi2n_f1 DOUT r0rx/M1 VSS VSS nfet L=0.13U W=1U
Dr1esd_Dp1 PAD$26 VDDIO dpantenna A=100P P=40U
Dr1esd_Dn1 VSS PAD$26 dantenna A=100P P=40U
Mr1esd_Mclamp_f0 VDDIO VSS VSS VSS nfet L=0.35U W=2U
Mr1esd_Mclamp_f1 VDDIO VSS VSS VSS nfet L=0.35U W=2U
Mr1esd_Mclamp_f2 VDDIO VSS VSS VSS nfet L=0.35U W=2U
Mr1esd_Mclamp_f3 VDDIO VSS VSS VSS nfet L=0.35U W=2U
Mr1esd_Mclamp_f4 VDDIO VSS VSS VSS nfet L=0.35U W=2U
Mr1esd_Mclamp_f5 VDDIO VSS VSS VSS nfet L=0.35U W=2U
Mr1esd_Mclamp_f6 VDDIO VSS VSS VSS nfet L=0.35U W=2U
Mr1esd_Mclamp_f7 VDDIO VSS VSS VSS nfet L=0.35U W=2U
Mr1esd_Mclamp_f8 VDDIO VSS VSS VSS nfet L=0.35U W=2U
Mr1esd_Mclamp_f9 VDDIO VSS VSS VSS nfet L=0.35U W=2U
Mr1esd_Mclamp_f10 VDDIO VSS VSS VSS nfet L=0.35U W=2U
Mr1esd_Mclamp_f11 VDDIO VSS VSS VSS nfet L=0.35U W=2U
Mr1esd_Mclamp_f12 VDDIO VSS VSS VSS nfet L=0.35U W=2U
Mr1esd_Mclamp_f13 VDDIO VSS VSS VSS nfet L=0.35U W=2U
Mr1esd_Mclamp_f14 VDDIO VSS VSS VSS nfet L=0.35U W=2U
Mr1esd_Mclamp_f15 VDDIO VSS VSS VSS nfet L=0.35U W=2U
Mr1esd_Mclamp_f16 VDDIO VSS VSS VSS nfet L=0.35U W=2U
Mr1esd_Mclamp_f17 VDDIO VSS VSS VSS nfet L=0.35U W=2U
Mr1esd_Mclamp_f18 VDDIO VSS VSS VSS nfet L=0.35U W=2U
Mr1esd_Mclamp_f19 VDDIO VSS VSS VSS nfet L=0.35U W=2U
Xr1esd_Resd PAD$26 PADI_R1 VSS rppd r=294.2 L=2U W=2U
Dr1esd_Dp2 PADI_R1 VDDIO dpantenna A=4P P=8U
Mr1esd_Mn2_f0 PADI_R1 VSS VSS VSS nfet L=0.13U W=1U
Mr1rx_Mi1p_f0 r1rx/M1 PADI_R1 VDDIO VDDIO pfet L=0.13U W=1.25U
Mr1rx_Mi1p_f1 r1rx/M1 PADI_R1 VDDIO VDDIO pfet L=0.13U W=1.25U
Mr1rx_Mi1n_f0 r1rx/M1 PADI_R1 VSS VSS nfet L=0.13U W=0.5U
Mr1rx_Mi1n_f1 r1rx/M1 PADI_R1 VSS VSS nfet L=0.13U W=0.5U
Mr1rx_Mi2p_f0 DOUT$1 r1rx/M1 VDDIO VDDIO pfet L=0.13U W=2U
Mr1rx_Mi2p_f1 DOUT$1 r1rx/M1 VDDIO VDDIO pfet L=0.13U W=2U
Mr1rx_Mi2n_f0 DOUT$1 r1rx/M1 VSS VSS nfet L=0.13U W=1U
Mr1rx_Mi2n_f1 DOUT$1 r1rx/M1 VSS VSS nfet L=0.13U W=1U
Dr2esd_Dp1 PAD$27 VDDIO dpantenna A=100P P=40U
Dr2esd_Dn1 VSS PAD$27 dantenna A=100P P=40U
Mr2esd_Mclamp_f0 VDDIO VSS VSS VSS nfet L=0.35U W=2U
Mr2esd_Mclamp_f1 VDDIO VSS VSS VSS nfet L=0.35U W=2U
Mr2esd_Mclamp_f2 VDDIO VSS VSS VSS nfet L=0.35U W=2U
Mr2esd_Mclamp_f3 VDDIO VSS VSS VSS nfet L=0.35U W=2U
Mr2esd_Mclamp_f4 VDDIO VSS VSS VSS nfet L=0.35U W=2U
Mr2esd_Mclamp_f5 VDDIO VSS VSS VSS nfet L=0.35U W=2U
Mr2esd_Mclamp_f6 VDDIO VSS VSS VSS nfet L=0.35U W=2U
Mr2esd_Mclamp_f7 VDDIO VSS VSS VSS nfet L=0.35U W=2U
Mr2esd_Mclamp_f8 VDDIO VSS VSS VSS nfet L=0.35U W=2U
Mr2esd_Mclamp_f9 VDDIO VSS VSS VSS nfet L=0.35U W=2U
Mr2esd_Mclamp_f10 VDDIO VSS VSS VSS nfet L=0.35U W=2U
Mr2esd_Mclamp_f11 VDDIO VSS VSS VSS nfet L=0.35U W=2U
Mr2esd_Mclamp_f12 VDDIO VSS VSS VSS nfet L=0.35U W=2U
Mr2esd_Mclamp_f13 VDDIO VSS VSS VSS nfet L=0.35U W=2U
Mr2esd_Mclamp_f14 VDDIO VSS VSS VSS nfet L=0.35U W=2U
Mr2esd_Mclamp_f15 VDDIO VSS VSS VSS nfet L=0.35U W=2U
Mr2esd_Mclamp_f16 VDDIO VSS VSS VSS nfet L=0.35U W=2U
Mr2esd_Mclamp_f17 VDDIO VSS VSS VSS nfet L=0.35U W=2U
Mr2esd_Mclamp_f18 VDDIO VSS VSS VSS nfet L=0.35U W=2U
Mr2esd_Mclamp_f19 VDDIO VSS VSS VSS nfet L=0.35U W=2U
Xr2esd_Resd PAD$27 PADI_R2 VSS rppd r=294.2 L=2U W=2U
Dr2esd_Dp2 PADI_R2 VDDIO dpantenna A=4P P=8U
Mr2esd_Mn2_f0 PADI_R2 VSS VSS VSS nfet L=0.13U W=1U
Mr2rx_Mi1p_f0 r2rx/M1 PADI_R2 VDDIO VDDIO pfet L=0.13U W=1.25U
Mr2rx_Mi1p_f1 r2rx/M1 PADI_R2 VDDIO VDDIO pfet L=0.13U W=1.25U
Mr2rx_Mi1n_f0 r2rx/M1 PADI_R2 VSS VSS nfet L=0.13U W=0.5U
Mr2rx_Mi1n_f1 r2rx/M1 PADI_R2 VSS VSS nfet L=0.13U W=0.5U
Mr2rx_Mi2p_f0 DOUT$2 r2rx/M1 VDDIO VDDIO pfet L=0.13U W=2U
Mr2rx_Mi2p_f1 DOUT$2 r2rx/M1 VDDIO VDDIO pfet L=0.13U W=2U
Mr2rx_Mi2n_f0 DOUT$2 r2rx/M1 VSS VSS nfet L=0.13U W=1U
Mr2rx_Mi2n_f1 DOUT$2 r2rx/M1 VSS VSS nfet L=0.13U W=1U
Dr3esd_Dp1 PAD$28 VDDIO dpantenna A=100P P=40U
Dr3esd_Dn1 VSS PAD$28 dantenna A=100P P=40U
Mr3esd_Mclamp_f0 VDDIO VSS VSS VSS nfet L=0.35U W=2U
Mr3esd_Mclamp_f1 VDDIO VSS VSS VSS nfet L=0.35U W=2U
Mr3esd_Mclamp_f2 VDDIO VSS VSS VSS nfet L=0.35U W=2U
Mr3esd_Mclamp_f3 VDDIO VSS VSS VSS nfet L=0.35U W=2U
Mr3esd_Mclamp_f4 VDDIO VSS VSS VSS nfet L=0.35U W=2U
Mr3esd_Mclamp_f5 VDDIO VSS VSS VSS nfet L=0.35U W=2U
Mr3esd_Mclamp_f6 VDDIO VSS VSS VSS nfet L=0.35U W=2U
Mr3esd_Mclamp_f7 VDDIO VSS VSS VSS nfet L=0.35U W=2U
Mr3esd_Mclamp_f8 VDDIO VSS VSS VSS nfet L=0.35U W=2U
Mr3esd_Mclamp_f9 VDDIO VSS VSS VSS nfet L=0.35U W=2U
Mr3esd_Mclamp_f10 VDDIO VSS VSS VSS nfet L=0.35U W=2U
Mr3esd_Mclamp_f11 VDDIO VSS VSS VSS nfet L=0.35U W=2U
Mr3esd_Mclamp_f12 VDDIO VSS VSS VSS nfet L=0.35U W=2U
Mr3esd_Mclamp_f13 VDDIO VSS VSS VSS nfet L=0.35U W=2U
Mr3esd_Mclamp_f14 VDDIO VSS VSS VSS nfet L=0.35U W=2U
Mr3esd_Mclamp_f15 VDDIO VSS VSS VSS nfet L=0.35U W=2U
Mr3esd_Mclamp_f16 VDDIO VSS VSS VSS nfet L=0.35U W=2U
Mr3esd_Mclamp_f17 VDDIO VSS VSS VSS nfet L=0.35U W=2U
Mr3esd_Mclamp_f18 VDDIO VSS VSS VSS nfet L=0.35U W=2U
Mr3esd_Mclamp_f19 VDDIO VSS VSS VSS nfet L=0.35U W=2U
Xr3esd_Resd PAD$28 PADI_R3 VSS rppd r=294.2 L=2U W=2U
Dr3esd_Dp2 PADI_R3 VDDIO dpantenna A=4P P=8U
Mr3esd_Mn2_f0 PADI_R3 VSS VSS VSS nfet L=0.13U W=1U
Mr3rx_Mi1p_f0 r3rx/M1 PADI_R3 VDDIO VDDIO pfet L=0.13U W=1.25U
Mr3rx_Mi1p_f1 r3rx/M1 PADI_R3 VDDIO VDDIO pfet L=0.13U W=1.25U
Mr3rx_Mi1n_f0 r3rx/M1 PADI_R3 VSS VSS nfet L=0.13U W=0.5U
Mr3rx_Mi1n_f1 r3rx/M1 PADI_R3 VSS VSS nfet L=0.13U W=0.5U
Mr3rx_Mi2p_f0 DOUT$3 r3rx/M1 VDDIO VDDIO pfet L=0.13U W=2U
Mr3rx_Mi2p_f1 DOUT$3 r3rx/M1 VDDIO VDDIO pfet L=0.13U W=2U
Mr3rx_Mi2n_f0 DOUT$3 r3rx/M1 VSS VSS nfet L=0.13U W=1U
Mr3rx_Mi2n_f1 DOUT$3 r3rx/M1 VSS VSS nfet L=0.13U W=1U
Dr4esd_Dp1 PAD$29 VDDIO dpantenna A=100P P=40U
Dr4esd_Dn1 VSS PAD$29 dantenna A=100P P=40U
Mr4esd_Mclamp_f0 VDDIO VSS VSS VSS nfet L=0.35U W=2U
Mr4esd_Mclamp_f1 VDDIO VSS VSS VSS nfet L=0.35U W=2U
Mr4esd_Mclamp_f2 VDDIO VSS VSS VSS nfet L=0.35U W=2U
Mr4esd_Mclamp_f3 VDDIO VSS VSS VSS nfet L=0.35U W=2U
Mr4esd_Mclamp_f4 VDDIO VSS VSS VSS nfet L=0.35U W=2U
Mr4esd_Mclamp_f5 VDDIO VSS VSS VSS nfet L=0.35U W=2U
Mr4esd_Mclamp_f6 VDDIO VSS VSS VSS nfet L=0.35U W=2U
Mr4esd_Mclamp_f7 VDDIO VSS VSS VSS nfet L=0.35U W=2U
Mr4esd_Mclamp_f8 VDDIO VSS VSS VSS nfet L=0.35U W=2U
Mr4esd_Mclamp_f9 VDDIO VSS VSS VSS nfet L=0.35U W=2U
Mr4esd_Mclamp_f10 VDDIO VSS VSS VSS nfet L=0.35U W=2U
Mr4esd_Mclamp_f11 VDDIO VSS VSS VSS nfet L=0.35U W=2U
Mr4esd_Mclamp_f12 VDDIO VSS VSS VSS nfet L=0.35U W=2U
Mr4esd_Mclamp_f13 VDDIO VSS VSS VSS nfet L=0.35U W=2U
Mr4esd_Mclamp_f14 VDDIO VSS VSS VSS nfet L=0.35U W=2U
Mr4esd_Mclamp_f15 VDDIO VSS VSS VSS nfet L=0.35U W=2U
Mr4esd_Mclamp_f16 VDDIO VSS VSS VSS nfet L=0.35U W=2U
Mr4esd_Mclamp_f17 VDDIO VSS VSS VSS nfet L=0.35U W=2U
Mr4esd_Mclamp_f18 VDDIO VSS VSS VSS nfet L=0.35U W=2U
Mr4esd_Mclamp_f19 VDDIO VSS VSS VSS nfet L=0.35U W=2U
Xr4esd_Resd PAD$29 PADI_R4 VSS rppd r=294.2 L=2U W=2U
Dr4esd_Dp2 PADI_R4 VDDIO dpantenna A=4P P=8U
Mr4esd_Mn2_f0 PADI_R4 VSS VSS VSS nfet L=0.13U W=1U
Mr4rx_Mi1p_f0 r4rx/M1 PADI_R4 VDDIO VDDIO pfet L=0.13U W=1.25U
Mr4rx_Mi1p_f1 r4rx/M1 PADI_R4 VDDIO VDDIO pfet L=0.13U W=1.25U
Mr4rx_Mi1n_f0 r4rx/M1 PADI_R4 VSS VSS nfet L=0.13U W=0.5U
Mr4rx_Mi1n_f1 r4rx/M1 PADI_R4 VSS VSS nfet L=0.13U W=0.5U
Mr4rx_Mi2p_f0 DOUT$4 r4rx/M1 VDDIO VDDIO pfet L=0.13U W=2U
Mr4rx_Mi2p_f1 DOUT$4 r4rx/M1 VDDIO VDDIO pfet L=0.13U W=2U
Mr4rx_Mi2n_f0 DOUT$4 r4rx/M1 VSS VSS nfet L=0.13U W=1U
Mr4rx_Mi2n_f1 DOUT$4 r4rx/M1 VSS VSS nfet L=0.13U W=1U
Dr5esd_Dp1 PAD$31 VDDIO dpantenna A=100P P=40U
Dr5esd_Dn1 VSS PAD$31 dantenna A=100P P=40U
Mr5esd_Mclamp_f0 VDDIO VSS VSS VSS nfet L=0.35U W=2U
Mr5esd_Mclamp_f1 VDDIO VSS VSS VSS nfet L=0.35U W=2U
Mr5esd_Mclamp_f2 VDDIO VSS VSS VSS nfet L=0.35U W=2U
Mr5esd_Mclamp_f3 VDDIO VSS VSS VSS nfet L=0.35U W=2U
Mr5esd_Mclamp_f4 VDDIO VSS VSS VSS nfet L=0.35U W=2U
Mr5esd_Mclamp_f5 VDDIO VSS VSS VSS nfet L=0.35U W=2U
Mr5esd_Mclamp_f6 VDDIO VSS VSS VSS nfet L=0.35U W=2U
Mr5esd_Mclamp_f7 VDDIO VSS VSS VSS nfet L=0.35U W=2U
Mr5esd_Mclamp_f8 VDDIO VSS VSS VSS nfet L=0.35U W=2U
Mr5esd_Mclamp_f9 VDDIO VSS VSS VSS nfet L=0.35U W=2U
Mr5esd_Mclamp_f10 VDDIO VSS VSS VSS nfet L=0.35U W=2U
Mr5esd_Mclamp_f11 VDDIO VSS VSS VSS nfet L=0.35U W=2U
Mr5esd_Mclamp_f12 VDDIO VSS VSS VSS nfet L=0.35U W=2U
Mr5esd_Mclamp_f13 VDDIO VSS VSS VSS nfet L=0.35U W=2U
Mr5esd_Mclamp_f14 VDDIO VSS VSS VSS nfet L=0.35U W=2U
Mr5esd_Mclamp_f15 VDDIO VSS VSS VSS nfet L=0.35U W=2U
Mr5esd_Mclamp_f16 VDDIO VSS VSS VSS nfet L=0.35U W=2U
Mr5esd_Mclamp_f17 VDDIO VSS VSS VSS nfet L=0.35U W=2U
Mr5esd_Mclamp_f18 VDDIO VSS VSS VSS nfet L=0.35U W=2U
Mr5esd_Mclamp_f19 VDDIO VSS VSS VSS nfet L=0.35U W=2U
Xr5esd_Resd PAD$31 PADI_R5 VSS rppd r=294.2 L=2U W=2U
Dr5esd_Dp2 PADI_R5 VDDIO dpantenna A=4P P=8U
Mr5esd_Mn2_f0 PADI_R5 VSS VSS VSS nfet L=0.13U W=1U
Mr5rx_Mi1p_f0 r5rx/M1 PADI_R5 VDDIO VDDIO pfet L=0.13U W=1.25U
Mr5rx_Mi1p_f1 r5rx/M1 PADI_R5 VDDIO VDDIO pfet L=0.13U W=1.25U
Mr5rx_Mi1n_f0 r5rx/M1 PADI_R5 VSS VSS nfet L=0.13U W=0.5U
Mr5rx_Mi1n_f1 r5rx/M1 PADI_R5 VSS VSS nfet L=0.13U W=0.5U
Mr5rx_Mi2p_f0 DOUT$5 r5rx/M1 VDDIO VDDIO pfet L=0.13U W=2U
Mr5rx_Mi2p_f1 DOUT$5 r5rx/M1 VDDIO VDDIO pfet L=0.13U W=2U
Mr5rx_Mi2n_f0 DOUT$5 r5rx/M1 VSS VSS nfet L=0.13U W=1U
Mr5rx_Mi2n_f1 DOUT$5 r5rx/M1 VSS VSS nfet L=0.13U W=1U
Dr6esd_Dp1 PAD$32 VDDIO dpantenna A=100P P=40U
Dr6esd_Dn1 VSS PAD$32 dantenna A=100P P=40U
Mr6esd_Mclamp_f0 VDDIO VSS VSS VSS nfet L=0.35U W=2U
Mr6esd_Mclamp_f1 VDDIO VSS VSS VSS nfet L=0.35U W=2U
Mr6esd_Mclamp_f2 VDDIO VSS VSS VSS nfet L=0.35U W=2U
Mr6esd_Mclamp_f3 VDDIO VSS VSS VSS nfet L=0.35U W=2U
Mr6esd_Mclamp_f4 VDDIO VSS VSS VSS nfet L=0.35U W=2U
Mr6esd_Mclamp_f5 VDDIO VSS VSS VSS nfet L=0.35U W=2U
Mr6esd_Mclamp_f6 VDDIO VSS VSS VSS nfet L=0.35U W=2U
Mr6esd_Mclamp_f7 VDDIO VSS VSS VSS nfet L=0.35U W=2U
Mr6esd_Mclamp_f8 VDDIO VSS VSS VSS nfet L=0.35U W=2U
Mr6esd_Mclamp_f9 VDDIO VSS VSS VSS nfet L=0.35U W=2U
Mr6esd_Mclamp_f10 VDDIO VSS VSS VSS nfet L=0.35U W=2U
Mr6esd_Mclamp_f11 VDDIO VSS VSS VSS nfet L=0.35U W=2U
Mr6esd_Mclamp_f12 VDDIO VSS VSS VSS nfet L=0.35U W=2U
Mr6esd_Mclamp_f13 VDDIO VSS VSS VSS nfet L=0.35U W=2U
Mr6esd_Mclamp_f14 VDDIO VSS VSS VSS nfet L=0.35U W=2U
Mr6esd_Mclamp_f15 VDDIO VSS VSS VSS nfet L=0.35U W=2U
Mr6esd_Mclamp_f16 VDDIO VSS VSS VSS nfet L=0.35U W=2U
Mr6esd_Mclamp_f17 VDDIO VSS VSS VSS nfet L=0.35U W=2U
Mr6esd_Mclamp_f18 VDDIO VSS VSS VSS nfet L=0.35U W=2U
Mr6esd_Mclamp_f19 VDDIO VSS VSS VSS nfet L=0.35U W=2U
Xr6esd_Resd PAD$32 PADI_R6 VSS rppd r=294.2 L=2U W=2U
Dr6esd_Dp2 PADI_R6 VDDIO dpantenna A=4P P=8U
Mr6esd_Mn2_f0 PADI_R6 VSS VSS VSS nfet L=0.13U W=1U
Mr6rx_Mi1p_f0 r6rx/M1 PADI_R6 VDDIO VDDIO pfet L=0.13U W=1.25U
Mr6rx_Mi1p_f1 r6rx/M1 PADI_R6 VDDIO VDDIO pfet L=0.13U W=1.25U
Mr6rx_Mi1n_f0 r6rx/M1 PADI_R6 VSS VSS nfet L=0.13U W=0.5U
Mr6rx_Mi1n_f1 r6rx/M1 PADI_R6 VSS VSS nfet L=0.13U W=0.5U
Mr6rx_Mi2p_f0 DOUT$6 r6rx/M1 VDDIO VDDIO pfet L=0.13U W=2U
Mr6rx_Mi2p_f1 DOUT$6 r6rx/M1 VDDIO VDDIO pfet L=0.13U W=2U
Mr6rx_Mi2n_f0 DOUT$6 r6rx/M1 VSS VSS nfet L=0.13U W=1U
Mr6rx_Mi2n_f1 DOUT$6 r6rx/M1 VSS VSS nfet L=0.13U W=1U
Dr7esd_Dp1 PAD$33 VDDIO dpantenna A=100P P=40U
Dr7esd_Dn1 VSS PAD$33 dantenna A=100P P=40U
Mr7esd_Mclamp_f0 VDDIO VSS VSS VSS nfet L=0.35U W=2U
Mr7esd_Mclamp_f1 VDDIO VSS VSS VSS nfet L=0.35U W=2U
Mr7esd_Mclamp_f2 VDDIO VSS VSS VSS nfet L=0.35U W=2U
Mr7esd_Mclamp_f3 VDDIO VSS VSS VSS nfet L=0.35U W=2U
Mr7esd_Mclamp_f4 VDDIO VSS VSS VSS nfet L=0.35U W=2U
Mr7esd_Mclamp_f5 VDDIO VSS VSS VSS nfet L=0.35U W=2U
Mr7esd_Mclamp_f6 VDDIO VSS VSS VSS nfet L=0.35U W=2U
Mr7esd_Mclamp_f7 VDDIO VSS VSS VSS nfet L=0.35U W=2U
Mr7esd_Mclamp_f8 VDDIO VSS VSS VSS nfet L=0.35U W=2U
Mr7esd_Mclamp_f9 VDDIO VSS VSS VSS nfet L=0.35U W=2U
Mr7esd_Mclamp_f10 VDDIO VSS VSS VSS nfet L=0.35U W=2U
Mr7esd_Mclamp_f11 VDDIO VSS VSS VSS nfet L=0.35U W=2U
Mr7esd_Mclamp_f12 VDDIO VSS VSS VSS nfet L=0.35U W=2U
Mr7esd_Mclamp_f13 VDDIO VSS VSS VSS nfet L=0.35U W=2U
Mr7esd_Mclamp_f14 VDDIO VSS VSS VSS nfet L=0.35U W=2U
Mr7esd_Mclamp_f15 VDDIO VSS VSS VSS nfet L=0.35U W=2U
Mr7esd_Mclamp_f16 VDDIO VSS VSS VSS nfet L=0.35U W=2U
Mr7esd_Mclamp_f17 VDDIO VSS VSS VSS nfet L=0.35U W=2U
Mr7esd_Mclamp_f18 VDDIO VSS VSS VSS nfet L=0.35U W=2U
Mr7esd_Mclamp_f19 VDDIO VSS VSS VSS nfet L=0.35U W=2U
Xr7esd_Resd PAD$33 PADI_R7 VSS rppd r=294.2 L=2U W=2U
Dr7esd_Dp2 PADI_R7 VDDIO dpantenna A=4P P=8U
Mr7esd_Mn2_f0 PADI_R7 VSS VSS VSS nfet L=0.13U W=1U
Mr7rx_Mi1p_f0 r7rx/M1 PADI_R7 VDDIO VDDIO pfet L=0.13U W=1.25U
Mr7rx_Mi1p_f1 r7rx/M1 PADI_R7 VDDIO VDDIO pfet L=0.13U W=1.25U
Mr7rx_Mi1n_f0 r7rx/M1 PADI_R7 VSS VSS nfet L=0.13U W=0.5U
Mr7rx_Mi1n_f1 r7rx/M1 PADI_R7 VSS VSS nfet L=0.13U W=0.5U
Mr7rx_Mi2p_f0 DOUT$7 r7rx/M1 VDDIO VDDIO pfet L=0.13U W=2U
Mr7rx_Mi2p_f1 DOUT$7 r7rx/M1 VDDIO VDDIO pfet L=0.13U W=2U
Mr7rx_Mi2n_f0 DOUT$7 r7rx/M1 VSS VSS nfet L=0.13U W=1U
Mr7rx_Mi2n_f1 DOUT$7 r7rx/M1 VSS VSS nfet L=0.13U W=1U
Dr8esd_Dp1 PAD$34 VDDIO dpantenna A=100P P=40U
Dr8esd_Dn1 VSS PAD$34 dantenna A=100P P=40U
Mr8esd_Mclamp_f0 VDDIO VSS VSS VSS nfet L=0.35U W=2U
Mr8esd_Mclamp_f1 VDDIO VSS VSS VSS nfet L=0.35U W=2U
Mr8esd_Mclamp_f2 VDDIO VSS VSS VSS nfet L=0.35U W=2U
Mr8esd_Mclamp_f3 VDDIO VSS VSS VSS nfet L=0.35U W=2U
Mr8esd_Mclamp_f4 VDDIO VSS VSS VSS nfet L=0.35U W=2U
Mr8esd_Mclamp_f5 VDDIO VSS VSS VSS nfet L=0.35U W=2U
Mr8esd_Mclamp_f6 VDDIO VSS VSS VSS nfet L=0.35U W=2U
Mr8esd_Mclamp_f7 VDDIO VSS VSS VSS nfet L=0.35U W=2U
Mr8esd_Mclamp_f8 VDDIO VSS VSS VSS nfet L=0.35U W=2U
Mr8esd_Mclamp_f9 VDDIO VSS VSS VSS nfet L=0.35U W=2U
Mr8esd_Mclamp_f10 VDDIO VSS VSS VSS nfet L=0.35U W=2U
Mr8esd_Mclamp_f11 VDDIO VSS VSS VSS nfet L=0.35U W=2U
Mr8esd_Mclamp_f12 VDDIO VSS VSS VSS nfet L=0.35U W=2U
Mr8esd_Mclamp_f13 VDDIO VSS VSS VSS nfet L=0.35U W=2U
Mr8esd_Mclamp_f14 VDDIO VSS VSS VSS nfet L=0.35U W=2U
Mr8esd_Mclamp_f15 VDDIO VSS VSS VSS nfet L=0.35U W=2U
Mr8esd_Mclamp_f16 VDDIO VSS VSS VSS nfet L=0.35U W=2U
Mr8esd_Mclamp_f17 VDDIO VSS VSS VSS nfet L=0.35U W=2U
Mr8esd_Mclamp_f18 VDDIO VSS VSS VSS nfet L=0.35U W=2U
Mr8esd_Mclamp_f19 VDDIO VSS VSS VSS nfet L=0.35U W=2U
Xr8esd_Resd PAD$34 PADI_R8 VSS rppd r=294.2 L=2U W=2U
Dr8esd_Dp2 PADI_R8 VDDIO dpantenna A=4P P=8U
Mr8esd_Mn2_f0 PADI_R8 VSS VSS VSS nfet L=0.13U W=1U
Mr8rx_Mi1p_f0 r8rx/M1 PADI_R8 VDDIO VDDIO pfet L=0.13U W=1.25U
Mr8rx_Mi1p_f1 r8rx/M1 PADI_R8 VDDIO VDDIO pfet L=0.13U W=1.25U
Mr8rx_Mi1n_f0 r8rx/M1 PADI_R8 VSS VSS nfet L=0.13U W=0.5U
Mr8rx_Mi1n_f1 r8rx/M1 PADI_R8 VSS VSS nfet L=0.13U W=0.5U
Mr8rx_Mi2p_f0 DOUT$8 r8rx/M1 VDDIO VDDIO pfet L=0.13U W=2U
Mr8rx_Mi2p_f1 DOUT$8 r8rx/M1 VDDIO VDDIO pfet L=0.13U W=2U
Mr8rx_Mi2n_f0 DOUT$8 r8rx/M1 VSS VSS nfet L=0.13U W=1U
Mr8rx_Mi2n_f1 DOUT$8 r8rx/M1 VSS VSS nfet L=0.13U W=1U
Dr9esd_Dp1 PAD$35 VDDIO dpantenna A=100P P=40U
Dr9esd_Dn1 VSS PAD$35 dantenna A=100P P=40U
Mr9esd_Mclamp_f0 VDDIO VSS VSS VSS nfet L=0.35U W=2U
Mr9esd_Mclamp_f1 VDDIO VSS VSS VSS nfet L=0.35U W=2U
Mr9esd_Mclamp_f2 VDDIO VSS VSS VSS nfet L=0.35U W=2U
Mr9esd_Mclamp_f3 VDDIO VSS VSS VSS nfet L=0.35U W=2U
Mr9esd_Mclamp_f4 VDDIO VSS VSS VSS nfet L=0.35U W=2U
Mr9esd_Mclamp_f5 VDDIO VSS VSS VSS nfet L=0.35U W=2U
Mr9esd_Mclamp_f6 VDDIO VSS VSS VSS nfet L=0.35U W=2U
Mr9esd_Mclamp_f7 VDDIO VSS VSS VSS nfet L=0.35U W=2U
Mr9esd_Mclamp_f8 VDDIO VSS VSS VSS nfet L=0.35U W=2U
Mr9esd_Mclamp_f9 VDDIO VSS VSS VSS nfet L=0.35U W=2U
Mr9esd_Mclamp_f10 VDDIO VSS VSS VSS nfet L=0.35U W=2U
Mr9esd_Mclamp_f11 VDDIO VSS VSS VSS nfet L=0.35U W=2U
Mr9esd_Mclamp_f12 VDDIO VSS VSS VSS nfet L=0.35U W=2U
Mr9esd_Mclamp_f13 VDDIO VSS VSS VSS nfet L=0.35U W=2U
Mr9esd_Mclamp_f14 VDDIO VSS VSS VSS nfet L=0.35U W=2U
Mr9esd_Mclamp_f15 VDDIO VSS VSS VSS nfet L=0.35U W=2U
Mr9esd_Mclamp_f16 VDDIO VSS VSS VSS nfet L=0.35U W=2U
Mr9esd_Mclamp_f17 VDDIO VSS VSS VSS nfet L=0.35U W=2U
Mr9esd_Mclamp_f18 VDDIO VSS VSS VSS nfet L=0.35U W=2U
Mr9esd_Mclamp_f19 VDDIO VSS VSS VSS nfet L=0.35U W=2U
Xr9esd_Resd PAD$35 PADI_R9 VSS rppd r=294.2 L=2U W=2U
Dr9esd_Dp2 PADI_R9 VDDIO dpantenna A=4P P=8U
Mr9esd_Mn2_f0 PADI_R9 VSS VSS VSS nfet L=0.13U W=1U
Mr9rx_Mi1p_f0 r9rx/M1 PADI_R9 VDDIO VDDIO pfet L=0.13U W=1.25U
Mr9rx_Mi1p_f1 r9rx/M1 PADI_R9 VDDIO VDDIO pfet L=0.13U W=1.25U
Mr9rx_Mi1n_f0 r9rx/M1 PADI_R9 VSS VSS nfet L=0.13U W=0.5U
Mr9rx_Mi1n_f1 r9rx/M1 PADI_R9 VSS VSS nfet L=0.13U W=0.5U
Mr9rx_Mi2p_f0 DOUT$9 r9rx/M1 VDDIO VDDIO pfet L=0.13U W=2U
Mr9rx_Mi2p_f1 DOUT$9 r9rx/M1 VDDIO VDDIO pfet L=0.13U W=2U
Mr9rx_Mi2n_f0 DOUT$9 r9rx/M1 VSS VSS nfet L=0.13U W=1U
Mr9rx_Mi2n_f1 DOUT$9 r9rx/M1 VSS VSS nfet L=0.13U W=1U
Dr10esd_Dp1 PAD$36 VDDIO dpantenna A=100P P=40U
Dr10esd_Dn1 VSS PAD$36 dantenna A=100P P=40U
Mr10esd_Mclamp_f0 VDDIO VSS VSS VSS nfet L=0.35U W=2U
Mr10esd_Mclamp_f1 VDDIO VSS VSS VSS nfet L=0.35U W=2U
Mr10esd_Mclamp_f2 VDDIO VSS VSS VSS nfet L=0.35U W=2U
Mr10esd_Mclamp_f3 VDDIO VSS VSS VSS nfet L=0.35U W=2U
Mr10esd_Mclamp_f4 VDDIO VSS VSS VSS nfet L=0.35U W=2U
Mr10esd_Mclamp_f5 VDDIO VSS VSS VSS nfet L=0.35U W=2U
Mr10esd_Mclamp_f6 VDDIO VSS VSS VSS nfet L=0.35U W=2U
Mr10esd_Mclamp_f7 VDDIO VSS VSS VSS nfet L=0.35U W=2U
Mr10esd_Mclamp_f8 VDDIO VSS VSS VSS nfet L=0.35U W=2U
Mr10esd_Mclamp_f9 VDDIO VSS VSS VSS nfet L=0.35U W=2U
Mr10esd_Mclamp_f10 VDDIO VSS VSS VSS nfet L=0.35U W=2U
Mr10esd_Mclamp_f11 VDDIO VSS VSS VSS nfet L=0.35U W=2U
Mr10esd_Mclamp_f12 VDDIO VSS VSS VSS nfet L=0.35U W=2U
Mr10esd_Mclamp_f13 VDDIO VSS VSS VSS nfet L=0.35U W=2U
Mr10esd_Mclamp_f14 VDDIO VSS VSS VSS nfet L=0.35U W=2U
Mr10esd_Mclamp_f15 VDDIO VSS VSS VSS nfet L=0.35U W=2U
Mr10esd_Mclamp_f16 VDDIO VSS VSS VSS nfet L=0.35U W=2U
Mr10esd_Mclamp_f17 VDDIO VSS VSS VSS nfet L=0.35U W=2U
Mr10esd_Mclamp_f18 VDDIO VSS VSS VSS nfet L=0.35U W=2U
Mr10esd_Mclamp_f19 VDDIO VSS VSS VSS nfet L=0.35U W=2U
Xr10esd_Resd PAD$36 PADI_R10 VSS rppd r=294.2 L=2U W=2U
Dr10esd_Dp2 PADI_R10 VDDIO dpantenna A=4P P=8U
Mr10esd_Mn2_f0 PADI_R10 VSS VSS VSS nfet L=0.13U W=1U
Mr10rx_Mi1p_f0 r10rx/M1 PADI_R10 VDDIO VDDIO pfet L=0.13U W=1.25U
Mr10rx_Mi1p_f1 r10rx/M1 PADI_R10 VDDIO VDDIO pfet L=0.13U W=1.25U
Mr10rx_Mi1n_f0 r10rx/M1 PADI_R10 VSS VSS nfet L=0.13U W=0.5U
Mr10rx_Mi1n_f1 r10rx/M1 PADI_R10 VSS VSS nfet L=0.13U W=0.5U
Mr10rx_Mi2p_f0 DOUT$10 r10rx/M1 VDDIO VDDIO pfet L=0.13U W=2U
Mr10rx_Mi2p_f1 DOUT$10 r10rx/M1 VDDIO VDDIO pfet L=0.13U W=2U
Mr10rx_Mi2n_f0 DOUT$10 r10rx/M1 VSS VSS nfet L=0.13U W=1U
Mr10rx_Mi2n_f1 DOUT$10 r10rx/M1 VSS VSS nfet L=0.13U W=1U
Dr11esd_Dp1 PAD$37 VDDIO dpantenna A=100P P=40U
Dr11esd_Dn1 VSS PAD$37 dantenna A=100P P=40U
Mr11esd_Mclamp_f0 VDDIO VSS VSS VSS nfet L=0.35U W=2U
Mr11esd_Mclamp_f1 VDDIO VSS VSS VSS nfet L=0.35U W=2U
Mr11esd_Mclamp_f2 VDDIO VSS VSS VSS nfet L=0.35U W=2U
Mr11esd_Mclamp_f3 VDDIO VSS VSS VSS nfet L=0.35U W=2U
Mr11esd_Mclamp_f4 VDDIO VSS VSS VSS nfet L=0.35U W=2U
Mr11esd_Mclamp_f5 VDDIO VSS VSS VSS nfet L=0.35U W=2U
Mr11esd_Mclamp_f6 VDDIO VSS VSS VSS nfet L=0.35U W=2U
Mr11esd_Mclamp_f7 VDDIO VSS VSS VSS nfet L=0.35U W=2U
Mr11esd_Mclamp_f8 VDDIO VSS VSS VSS nfet L=0.35U W=2U
Mr11esd_Mclamp_f9 VDDIO VSS VSS VSS nfet L=0.35U W=2U
Mr11esd_Mclamp_f10 VDDIO VSS VSS VSS nfet L=0.35U W=2U
Mr11esd_Mclamp_f11 VDDIO VSS VSS VSS nfet L=0.35U W=2U
Mr11esd_Mclamp_f12 VDDIO VSS VSS VSS nfet L=0.35U W=2U
Mr11esd_Mclamp_f13 VDDIO VSS VSS VSS nfet L=0.35U W=2U
Mr11esd_Mclamp_f14 VDDIO VSS VSS VSS nfet L=0.35U W=2U
Mr11esd_Mclamp_f15 VDDIO VSS VSS VSS nfet L=0.35U W=2U
Mr11esd_Mclamp_f16 VDDIO VSS VSS VSS nfet L=0.35U W=2U
Mr11esd_Mclamp_f17 VDDIO VSS VSS VSS nfet L=0.35U W=2U
Mr11esd_Mclamp_f18 VDDIO VSS VSS VSS nfet L=0.35U W=2U
Mr11esd_Mclamp_f19 VDDIO VSS VSS VSS nfet L=0.35U W=2U
Xr11esd_Resd PAD$37 PADI_R11 VSS rppd r=294.2 L=2U W=2U
Dr11esd_Dp2 PADI_R11 VDDIO dpantenna A=4P P=8U
Mr11esd_Mn2_f0 PADI_R11 VSS VSS VSS nfet L=0.13U W=1U
Mr11rx_Mi1p_f0 r11rx/M1 PADI_R11 VDDIO VDDIO pfet L=0.13U W=1.25U
Mr11rx_Mi1p_f1 r11rx/M1 PADI_R11 VDDIO VDDIO pfet L=0.13U W=1.25U
Mr11rx_Mi1n_f0 r11rx/M1 PADI_R11 VSS VSS nfet L=0.13U W=0.5U
Mr11rx_Mi1n_f1 r11rx/M1 PADI_R11 VSS VSS nfet L=0.13U W=0.5U
Mr11rx_Mi2p_f0 DOUT$11 r11rx/M1 VDDIO VDDIO pfet L=0.13U W=2U
Mr11rx_Mi2p_f1 DOUT$11 r11rx/M1 VDDIO VDDIO pfet L=0.13U W=2U
Mr11rx_Mi2n_f0 DOUT$11 r11rx/M1 VSS VSS nfet L=0.13U W=1U
Mr11rx_Mi2n_f1 DOUT$11 r11rx/M1 VSS VSS nfet L=0.13U W=1U
Dr12esd_Dp1 PAD$38 VDDIO dpantenna A=100P P=40U
Dr12esd_Dn1 VSS PAD$38 dantenna A=100P P=40U
Mr12esd_Mclamp_f0 VDDIO VSS VSS VSS nfet L=0.35U W=2U
Mr12esd_Mclamp_f1 VDDIO VSS VSS VSS nfet L=0.35U W=2U
Mr12esd_Mclamp_f2 VDDIO VSS VSS VSS nfet L=0.35U W=2U
Mr12esd_Mclamp_f3 VDDIO VSS VSS VSS nfet L=0.35U W=2U
Mr12esd_Mclamp_f4 VDDIO VSS VSS VSS nfet L=0.35U W=2U
Mr12esd_Mclamp_f5 VDDIO VSS VSS VSS nfet L=0.35U W=2U
Mr12esd_Mclamp_f6 VDDIO VSS VSS VSS nfet L=0.35U W=2U
Mr12esd_Mclamp_f7 VDDIO VSS VSS VSS nfet L=0.35U W=2U
Mr12esd_Mclamp_f8 VDDIO VSS VSS VSS nfet L=0.35U W=2U
Mr12esd_Mclamp_f9 VDDIO VSS VSS VSS nfet L=0.35U W=2U
Mr12esd_Mclamp_f10 VDDIO VSS VSS VSS nfet L=0.35U W=2U
Mr12esd_Mclamp_f11 VDDIO VSS VSS VSS nfet L=0.35U W=2U
Mr12esd_Mclamp_f12 VDDIO VSS VSS VSS nfet L=0.35U W=2U
Mr12esd_Mclamp_f13 VDDIO VSS VSS VSS nfet L=0.35U W=2U
Mr12esd_Mclamp_f14 VDDIO VSS VSS VSS nfet L=0.35U W=2U
Mr12esd_Mclamp_f15 VDDIO VSS VSS VSS nfet L=0.35U W=2U
Mr12esd_Mclamp_f16 VDDIO VSS VSS VSS nfet L=0.35U W=2U
Mr12esd_Mclamp_f17 VDDIO VSS VSS VSS nfet L=0.35U W=2U
Mr12esd_Mclamp_f18 VDDIO VSS VSS VSS nfet L=0.35U W=2U
Mr12esd_Mclamp_f19 VDDIO VSS VSS VSS nfet L=0.35U W=2U
Xr12esd_Resd PAD$38 PADI_R12 VSS rppd r=294.2 L=2U W=2U
Dr12esd_Dp2 PADI_R12 VDDIO dpantenna A=4P P=8U
Mr12esd_Mn2_f0 PADI_R12 VSS VSS VSS nfet L=0.13U W=1U
Mr12rx_Mi1p_f0 r12rx/M1 PADI_R12 VDDIO VDDIO pfet L=0.13U W=1.25U
Mr12rx_Mi1p_f1 r12rx/M1 PADI_R12 VDDIO VDDIO pfet L=0.13U W=1.25U
Mr12rx_Mi1n_f0 r12rx/M1 PADI_R12 VSS VSS nfet L=0.13U W=0.5U
Mr12rx_Mi1n_f1 r12rx/M1 PADI_R12 VSS VSS nfet L=0.13U W=0.5U
Mr12rx_Mi2p_f0 DOUT$12 r12rx/M1 VDDIO VDDIO pfet L=0.13U W=2U
Mr12rx_Mi2p_f1 DOUT$12 r12rx/M1 VDDIO VDDIO pfet L=0.13U W=2U
Mr12rx_Mi2n_f0 DOUT$12 r12rx/M1 VSS VSS nfet L=0.13U W=1U
Mr12rx_Mi2n_f1 DOUT$12 r12rx/M1 VSS VSS nfet L=0.13U W=1U
Dr13esd_Dp1 PAD$39 VDDIO dpantenna A=100P P=40U
Dr13esd_Dn1 VSS PAD$39 dantenna A=100P P=40U
Mr13esd_Mclamp_f0 VDDIO VSS VSS VSS nfet L=0.35U W=2U
Mr13esd_Mclamp_f1 VDDIO VSS VSS VSS nfet L=0.35U W=2U
Mr13esd_Mclamp_f2 VDDIO VSS VSS VSS nfet L=0.35U W=2U
Mr13esd_Mclamp_f3 VDDIO VSS VSS VSS nfet L=0.35U W=2U
Mr13esd_Mclamp_f4 VDDIO VSS VSS VSS nfet L=0.35U W=2U
Mr13esd_Mclamp_f5 VDDIO VSS VSS VSS nfet L=0.35U W=2U
Mr13esd_Mclamp_f6 VDDIO VSS VSS VSS nfet L=0.35U W=2U
Mr13esd_Mclamp_f7 VDDIO VSS VSS VSS nfet L=0.35U W=2U
Mr13esd_Mclamp_f8 VDDIO VSS VSS VSS nfet L=0.35U W=2U
Mr13esd_Mclamp_f9 VDDIO VSS VSS VSS nfet L=0.35U W=2U
Mr13esd_Mclamp_f10 VDDIO VSS VSS VSS nfet L=0.35U W=2U
Mr13esd_Mclamp_f11 VDDIO VSS VSS VSS nfet L=0.35U W=2U
Mr13esd_Mclamp_f12 VDDIO VSS VSS VSS nfet L=0.35U W=2U
Mr13esd_Mclamp_f13 VDDIO VSS VSS VSS nfet L=0.35U W=2U
Mr13esd_Mclamp_f14 VDDIO VSS VSS VSS nfet L=0.35U W=2U
Mr13esd_Mclamp_f15 VDDIO VSS VSS VSS nfet L=0.35U W=2U
Mr13esd_Mclamp_f16 VDDIO VSS VSS VSS nfet L=0.35U W=2U
Mr13esd_Mclamp_f17 VDDIO VSS VSS VSS nfet L=0.35U W=2U
Mr13esd_Mclamp_f18 VDDIO VSS VSS VSS nfet L=0.35U W=2U
Mr13esd_Mclamp_f19 VDDIO VSS VSS VSS nfet L=0.35U W=2U
Xr13esd_Resd PAD$39 PADI_R13 VSS rppd r=294.2 L=2U W=2U
Dr13esd_Dp2 PADI_R13 VDDIO dpantenna A=4P P=8U
Mr13esd_Mn2_f0 PADI_R13 VSS VSS VSS nfet L=0.13U W=1U
Mr13rx_Mi1p_f0 r13rx/M1 PADI_R13 VDDIO VDDIO pfet L=0.13U W=1.25U
Mr13rx_Mi1p_f1 r13rx/M1 PADI_R13 VDDIO VDDIO pfet L=0.13U W=1.25U
Mr13rx_Mi1n_f0 r13rx/M1 PADI_R13 VSS VSS nfet L=0.13U W=0.5U
Mr13rx_Mi1n_f1 r13rx/M1 PADI_R13 VSS VSS nfet L=0.13U W=0.5U
Mr13rx_Mi2p_f0 DOUT$13 r13rx/M1 VDDIO VDDIO pfet L=0.13U W=2U
Mr13rx_Mi2p_f1 DOUT$13 r13rx/M1 VDDIO VDDIO pfet L=0.13U W=2U
Mr13rx_Mi2n_f0 DOUT$13 r13rx/M1 VSS VSS nfet L=0.13U W=1U
Mr13rx_Mi2n_f1 DOUT$13 r13rx/M1 VSS VSS nfet L=0.13U W=1U
Dr14esd_Dp1 PAD$40 VDDIO dpantenna A=100P P=40U
Dr14esd_Dn1 VSS PAD$40 dantenna A=100P P=40U
Mr14esd_Mclamp_f0 VDDIO VSS VSS VSS nfet L=0.35U W=2U
Mr14esd_Mclamp_f1 VDDIO VSS VSS VSS nfet L=0.35U W=2U
Mr14esd_Mclamp_f2 VDDIO VSS VSS VSS nfet L=0.35U W=2U
Mr14esd_Mclamp_f3 VDDIO VSS VSS VSS nfet L=0.35U W=2U
Mr14esd_Mclamp_f4 VDDIO VSS VSS VSS nfet L=0.35U W=2U
Mr14esd_Mclamp_f5 VDDIO VSS VSS VSS nfet L=0.35U W=2U
Mr14esd_Mclamp_f6 VDDIO VSS VSS VSS nfet L=0.35U W=2U
Mr14esd_Mclamp_f7 VDDIO VSS VSS VSS nfet L=0.35U W=2U
Mr14esd_Mclamp_f8 VDDIO VSS VSS VSS nfet L=0.35U W=2U
Mr14esd_Mclamp_f9 VDDIO VSS VSS VSS nfet L=0.35U W=2U
Mr14esd_Mclamp_f10 VDDIO VSS VSS VSS nfet L=0.35U W=2U
Mr14esd_Mclamp_f11 VDDIO VSS VSS VSS nfet L=0.35U W=2U
Mr14esd_Mclamp_f12 VDDIO VSS VSS VSS nfet L=0.35U W=2U
Mr14esd_Mclamp_f13 VDDIO VSS VSS VSS nfet L=0.35U W=2U
Mr14esd_Mclamp_f14 VDDIO VSS VSS VSS nfet L=0.35U W=2U
Mr14esd_Mclamp_f15 VDDIO VSS VSS VSS nfet L=0.35U W=2U
Mr14esd_Mclamp_f16 VDDIO VSS VSS VSS nfet L=0.35U W=2U
Mr14esd_Mclamp_f17 VDDIO VSS VSS VSS nfet L=0.35U W=2U
Mr14esd_Mclamp_f18 VDDIO VSS VSS VSS nfet L=0.35U W=2U
Mr14esd_Mclamp_f19 VDDIO VSS VSS VSS nfet L=0.35U W=2U
Xr14esd_Resd PAD$40 PADI_R14 VSS rppd r=294.2 L=2U W=2U
Dr14esd_Dp2 PADI_R14 VDDIO dpantenna A=4P P=8U
Mr14esd_Mn2_f0 PADI_R14 VSS VSS VSS nfet L=0.13U W=1U
Mr14rx_Mi1p_f0 r14rx/M1 PADI_R14 VDDIO VDDIO pfet L=0.13U W=1.25U
Mr14rx_Mi1p_f1 r14rx/M1 PADI_R14 VDDIO VDDIO pfet L=0.13U W=1.25U
Mr14rx_Mi1n_f0 r14rx/M1 PADI_R14 VSS VSS nfet L=0.13U W=0.5U
Mr14rx_Mi1n_f1 r14rx/M1 PADI_R14 VSS VSS nfet L=0.13U W=0.5U
Mr14rx_Mi2p_f0 DOUT$14 r14rx/M1 VDDIO VDDIO pfet L=0.13U W=2U
Mr14rx_Mi2p_f1 DOUT$14 r14rx/M1 VDDIO VDDIO pfet L=0.13U W=2U
Mr14rx_Mi2n_f0 DOUT$14 r14rx/M1 VSS VSS nfet L=0.13U W=1U
Mr14rx_Mi2n_f1 DOUT$14 r14rx/M1 VSS VSS nfet L=0.13U W=1U
Dr15esd_Dp1 PAD$41 VDDIO dpantenna A=100P P=40U
Dr15esd_Dn1 VSS PAD$41 dantenna A=100P P=40U
Mr15esd_Mclamp_f0 VDDIO VSS VSS VSS nfet L=0.35U W=2U
Mr15esd_Mclamp_f1 VDDIO VSS VSS VSS nfet L=0.35U W=2U
Mr15esd_Mclamp_f2 VDDIO VSS VSS VSS nfet L=0.35U W=2U
Mr15esd_Mclamp_f3 VDDIO VSS VSS VSS nfet L=0.35U W=2U
Mr15esd_Mclamp_f4 VDDIO VSS VSS VSS nfet L=0.35U W=2U
Mr15esd_Mclamp_f5 VDDIO VSS VSS VSS nfet L=0.35U W=2U
Mr15esd_Mclamp_f6 VDDIO VSS VSS VSS nfet L=0.35U W=2U
Mr15esd_Mclamp_f7 VDDIO VSS VSS VSS nfet L=0.35U W=2U
Mr15esd_Mclamp_f8 VDDIO VSS VSS VSS nfet L=0.35U W=2U
Mr15esd_Mclamp_f9 VDDIO VSS VSS VSS nfet L=0.35U W=2U
Mr15esd_Mclamp_f10 VDDIO VSS VSS VSS nfet L=0.35U W=2U
Mr15esd_Mclamp_f11 VDDIO VSS VSS VSS nfet L=0.35U W=2U
Mr15esd_Mclamp_f12 VDDIO VSS VSS VSS nfet L=0.35U W=2U
Mr15esd_Mclamp_f13 VDDIO VSS VSS VSS nfet L=0.35U W=2U
Mr15esd_Mclamp_f14 VDDIO VSS VSS VSS nfet L=0.35U W=2U
Mr15esd_Mclamp_f15 VDDIO VSS VSS VSS nfet L=0.35U W=2U
Mr15esd_Mclamp_f16 VDDIO VSS VSS VSS nfet L=0.35U W=2U
Mr15esd_Mclamp_f17 VDDIO VSS VSS VSS nfet L=0.35U W=2U
Mr15esd_Mclamp_f18 VDDIO VSS VSS VSS nfet L=0.35U W=2U
Mr15esd_Mclamp_f19 VDDIO VSS VSS VSS nfet L=0.35U W=2U
Xr15esd_Resd PAD$41 PADI_R15 VSS rppd r=294.2 L=2U W=2U
Dr15esd_Dp2 PADI_R15 VDDIO dpantenna A=4P P=8U
Mr15esd_Mn2_f0 PADI_R15 VSS VSS VSS nfet L=0.13U W=1U
Mr15rx_Mi1p_f0 r15rx/M1 PADI_R15 VDDIO VDDIO pfet L=0.13U W=1.25U
Mr15rx_Mi1p_f1 r15rx/M1 PADI_R15 VDDIO VDDIO pfet L=0.13U W=1.25U
Mr15rx_Mi1n_f0 r15rx/M1 PADI_R15 VSS VSS nfet L=0.13U W=0.5U
Mr15rx_Mi1n_f1 r15rx/M1 PADI_R15 VSS VSS nfet L=0.13U W=0.5U
Mr15rx_Mi2p_f0 DOUT$15 r15rx/M1 VDDIO VDDIO pfet L=0.13U W=2U
Mr15rx_Mi2p_f1 DOUT$15 r15rx/M1 VDDIO VDDIO pfet L=0.13U W=2U
Mr15rx_Mi2n_f0 DOUT$15 r15rx/M1 VSS VSS nfet L=0.13U W=1U
Mr15rx_Mi2n_f1 DOUT$15 r15rx/M1 VSS VSS nfet L=0.13U W=1U
Dr16esd_Dp1 PAD$42 VDDIO dpantenna A=100P P=40U
Dr16esd_Dn1 VSS PAD$42 dantenna A=100P P=40U
Mr16esd_Mclamp_f0 VDDIO VSS VSS VSS nfet L=0.35U W=2U
Mr16esd_Mclamp_f1 VDDIO VSS VSS VSS nfet L=0.35U W=2U
Mr16esd_Mclamp_f2 VDDIO VSS VSS VSS nfet L=0.35U W=2U
Mr16esd_Mclamp_f3 VDDIO VSS VSS VSS nfet L=0.35U W=2U
Mr16esd_Mclamp_f4 VDDIO VSS VSS VSS nfet L=0.35U W=2U
Mr16esd_Mclamp_f5 VDDIO VSS VSS VSS nfet L=0.35U W=2U
Mr16esd_Mclamp_f6 VDDIO VSS VSS VSS nfet L=0.35U W=2U
Mr16esd_Mclamp_f7 VDDIO VSS VSS VSS nfet L=0.35U W=2U
Mr16esd_Mclamp_f8 VDDIO VSS VSS VSS nfet L=0.35U W=2U
Mr16esd_Mclamp_f9 VDDIO VSS VSS VSS nfet L=0.35U W=2U
Mr16esd_Mclamp_f10 VDDIO VSS VSS VSS nfet L=0.35U W=2U
Mr16esd_Mclamp_f11 VDDIO VSS VSS VSS nfet L=0.35U W=2U
Mr16esd_Mclamp_f12 VDDIO VSS VSS VSS nfet L=0.35U W=2U
Mr16esd_Mclamp_f13 VDDIO VSS VSS VSS nfet L=0.35U W=2U
Mr16esd_Mclamp_f14 VDDIO VSS VSS VSS nfet L=0.35U W=2U
Mr16esd_Mclamp_f15 VDDIO VSS VSS VSS nfet L=0.35U W=2U
Mr16esd_Mclamp_f16 VDDIO VSS VSS VSS nfet L=0.35U W=2U
Mr16esd_Mclamp_f17 VDDIO VSS VSS VSS nfet L=0.35U W=2U
Mr16esd_Mclamp_f18 VDDIO VSS VSS VSS nfet L=0.35U W=2U
Mr16esd_Mclamp_f19 VDDIO VSS VSS VSS nfet L=0.35U W=2U
Xr16esd_Resd PAD$42 PADI_R16 VSS rppd r=294.2 L=2U W=2U
Dr16esd_Dp2 PADI_R16 VDDIO dpantenna A=4P P=8U
Mr16esd_Mn2_f0 PADI_R16 VSS VSS VSS nfet L=0.13U W=1U
Mr16rx_Mi1p_f0 r16rx/M1 PADI_R16 VDDIO VDDIO pfet L=0.13U W=1.25U
Mr16rx_Mi1p_f1 r16rx/M1 PADI_R16 VDDIO VDDIO pfet L=0.13U W=1.25U
Mr16rx_Mi1n_f0 r16rx/M1 PADI_R16 VSS VSS nfet L=0.13U W=0.5U
Mr16rx_Mi1n_f1 r16rx/M1 PADI_R16 VSS VSS nfet L=0.13U W=0.5U
Mr16rx_Mi2p_f0 DOUT$16 r16rx/M1 VDDIO VDDIO pfet L=0.13U W=2U
Mr16rx_Mi2p_f1 DOUT$16 r16rx/M1 VDDIO VDDIO pfet L=0.13U W=2U
Mr16rx_Mi2n_f0 DOUT$16 r16rx/M1 VSS VSS nfet L=0.13U W=1U
Mr16rx_Mi2n_f1 DOUT$16 r16rx/M1 VSS VSS nfet L=0.13U W=1U
Dr17esd_Dp1 PAD$43 VDDIO dpantenna A=100P P=40U
Dr17esd_Dn1 VSS PAD$43 dantenna A=100P P=40U
Mr17esd_Mclamp_f0 VDDIO VSS VSS VSS nfet L=0.35U W=2U
Mr17esd_Mclamp_f1 VDDIO VSS VSS VSS nfet L=0.35U W=2U
Mr17esd_Mclamp_f2 VDDIO VSS VSS VSS nfet L=0.35U W=2U
Mr17esd_Mclamp_f3 VDDIO VSS VSS VSS nfet L=0.35U W=2U
Mr17esd_Mclamp_f4 VDDIO VSS VSS VSS nfet L=0.35U W=2U
Mr17esd_Mclamp_f5 VDDIO VSS VSS VSS nfet L=0.35U W=2U
Mr17esd_Mclamp_f6 VDDIO VSS VSS VSS nfet L=0.35U W=2U
Mr17esd_Mclamp_f7 VDDIO VSS VSS VSS nfet L=0.35U W=2U
Mr17esd_Mclamp_f8 VDDIO VSS VSS VSS nfet L=0.35U W=2U
Mr17esd_Mclamp_f9 VDDIO VSS VSS VSS nfet L=0.35U W=2U
Mr17esd_Mclamp_f10 VDDIO VSS VSS VSS nfet L=0.35U W=2U
Mr17esd_Mclamp_f11 VDDIO VSS VSS VSS nfet L=0.35U W=2U
Mr17esd_Mclamp_f12 VDDIO VSS VSS VSS nfet L=0.35U W=2U
Mr17esd_Mclamp_f13 VDDIO VSS VSS VSS nfet L=0.35U W=2U
Mr17esd_Mclamp_f14 VDDIO VSS VSS VSS nfet L=0.35U W=2U
Mr17esd_Mclamp_f15 VDDIO VSS VSS VSS nfet L=0.35U W=2U
Mr17esd_Mclamp_f16 VDDIO VSS VSS VSS nfet L=0.35U W=2U
Mr17esd_Mclamp_f17 VDDIO VSS VSS VSS nfet L=0.35U W=2U
Mr17esd_Mclamp_f18 VDDIO VSS VSS VSS nfet L=0.35U W=2U
Mr17esd_Mclamp_f19 VDDIO VSS VSS VSS nfet L=0.35U W=2U
Xr17esd_Resd PAD$43 PADI_R17 VSS rppd r=294.2 L=2U W=2U
Dr17esd_Dp2 PADI_R17 VDDIO dpantenna A=4P P=8U
Mr17esd_Mn2_f0 PADI_R17 VSS VSS VSS nfet L=0.13U W=1U
Mr17rx_Mi1p_f0 r17rx/M1 PADI_R17 VDDIO VDDIO pfet L=0.13U W=1.25U
Mr17rx_Mi1p_f1 r17rx/M1 PADI_R17 VDDIO VDDIO pfet L=0.13U W=1.25U
Mr17rx_Mi1n_f0 r17rx/M1 PADI_R17 VSS VSS nfet L=0.13U W=0.5U
Mr17rx_Mi1n_f1 r17rx/M1 PADI_R17 VSS VSS nfet L=0.13U W=0.5U
Mr17rx_Mi2p_f0 DOUT$17 r17rx/M1 VDDIO VDDIO pfet L=0.13U W=2U
Mr17rx_Mi2p_f1 DOUT$17 r17rx/M1 VDDIO VDDIO pfet L=0.13U W=2U
Mr17rx_Mi2n_f0 DOUT$17 r17rx/M1 VSS VSS nfet L=0.13U W=1U
Mr17rx_Mi2n_f1 DOUT$17 r17rx/M1 VSS VSS nfet L=0.13U W=1U
Dr18esd_Dp1 PAD$44 VDDIO dpantenna A=100P P=40U
Dr18esd_Dn1 VSS PAD$44 dantenna A=100P P=40U
Mr18esd_Mclamp_f0 VDDIO VSS VSS VSS nfet L=0.35U W=2U
Mr18esd_Mclamp_f1 VDDIO VSS VSS VSS nfet L=0.35U W=2U
Mr18esd_Mclamp_f2 VDDIO VSS VSS VSS nfet L=0.35U W=2U
Mr18esd_Mclamp_f3 VDDIO VSS VSS VSS nfet L=0.35U W=2U
Mr18esd_Mclamp_f4 VDDIO VSS VSS VSS nfet L=0.35U W=2U
Mr18esd_Mclamp_f5 VDDIO VSS VSS VSS nfet L=0.35U W=2U
Mr18esd_Mclamp_f6 VDDIO VSS VSS VSS nfet L=0.35U W=2U
Mr18esd_Mclamp_f7 VDDIO VSS VSS VSS nfet L=0.35U W=2U
Mr18esd_Mclamp_f8 VDDIO VSS VSS VSS nfet L=0.35U W=2U
Mr18esd_Mclamp_f9 VDDIO VSS VSS VSS nfet L=0.35U W=2U
Mr18esd_Mclamp_f10 VDDIO VSS VSS VSS nfet L=0.35U W=2U
Mr18esd_Mclamp_f11 VDDIO VSS VSS VSS nfet L=0.35U W=2U
Mr18esd_Mclamp_f12 VDDIO VSS VSS VSS nfet L=0.35U W=2U
Mr18esd_Mclamp_f13 VDDIO VSS VSS VSS nfet L=0.35U W=2U
Mr18esd_Mclamp_f14 VDDIO VSS VSS VSS nfet L=0.35U W=2U
Mr18esd_Mclamp_f15 VDDIO VSS VSS VSS nfet L=0.35U W=2U
Mr18esd_Mclamp_f16 VDDIO VSS VSS VSS nfet L=0.35U W=2U
Mr18esd_Mclamp_f17 VDDIO VSS VSS VSS nfet L=0.35U W=2U
Mr18esd_Mclamp_f18 VDDIO VSS VSS VSS nfet L=0.35U W=2U
Mr18esd_Mclamp_f19 VDDIO VSS VSS VSS nfet L=0.35U W=2U
Xr18esd_Resd PAD$44 PADI_R18 VSS rppd r=294.2 L=2U W=2U
Dr18esd_Dp2 PADI_R18 VDDIO dpantenna A=4P P=8U
Mr18esd_Mn2_f0 PADI_R18 VSS VSS VSS nfet L=0.13U W=1U
Mr18rx_Mi1p_f0 r18rx/M1 PADI_R18 VDDIO VDDIO pfet L=0.13U W=1.25U
Mr18rx_Mi1p_f1 r18rx/M1 PADI_R18 VDDIO VDDIO pfet L=0.13U W=1.25U
Mr18rx_Mi1n_f0 r18rx/M1 PADI_R18 VSS VSS nfet L=0.13U W=0.5U
Mr18rx_Mi1n_f1 r18rx/M1 PADI_R18 VSS VSS nfet L=0.13U W=0.5U
Mr18rx_Mi2p_f0 DOUT$18 r18rx/M1 VDDIO VDDIO pfet L=0.13U W=2U
Mr18rx_Mi2p_f1 DOUT$18 r18rx/M1 VDDIO VDDIO pfet L=0.13U W=2U
Mr18rx_Mi2n_f0 DOUT$18 r18rx/M1 VSS VSS nfet L=0.13U W=1U
Mr18rx_Mi2n_f1 DOUT$18 r18rx/M1 VSS VSS nfet L=0.13U W=1U
Dr19esd_Dp1 PAD$45 VDDIO dpantenna A=100P P=40U
Dr19esd_Dn1 VSS PAD$45 dantenna A=100P P=40U
Mr19esd_Mclamp_f0 VDDIO VSS VSS VSS nfet L=0.35U W=2U
Mr19esd_Mclamp_f1 VDDIO VSS VSS VSS nfet L=0.35U W=2U
Mr19esd_Mclamp_f2 VDDIO VSS VSS VSS nfet L=0.35U W=2U
Mr19esd_Mclamp_f3 VDDIO VSS VSS VSS nfet L=0.35U W=2U
Mr19esd_Mclamp_f4 VDDIO VSS VSS VSS nfet L=0.35U W=2U
Mr19esd_Mclamp_f5 VDDIO VSS VSS VSS nfet L=0.35U W=2U
Mr19esd_Mclamp_f6 VDDIO VSS VSS VSS nfet L=0.35U W=2U
Mr19esd_Mclamp_f7 VDDIO VSS VSS VSS nfet L=0.35U W=2U
Mr19esd_Mclamp_f8 VDDIO VSS VSS VSS nfet L=0.35U W=2U
Mr19esd_Mclamp_f9 VDDIO VSS VSS VSS nfet L=0.35U W=2U
Mr19esd_Mclamp_f10 VDDIO VSS VSS VSS nfet L=0.35U W=2U
Mr19esd_Mclamp_f11 VDDIO VSS VSS VSS nfet L=0.35U W=2U
Mr19esd_Mclamp_f12 VDDIO VSS VSS VSS nfet L=0.35U W=2U
Mr19esd_Mclamp_f13 VDDIO VSS VSS VSS nfet L=0.35U W=2U
Mr19esd_Mclamp_f14 VDDIO VSS VSS VSS nfet L=0.35U W=2U
Mr19esd_Mclamp_f15 VDDIO VSS VSS VSS nfet L=0.35U W=2U
Mr19esd_Mclamp_f16 VDDIO VSS VSS VSS nfet L=0.35U W=2U
Mr19esd_Mclamp_f17 VDDIO VSS VSS VSS nfet L=0.35U W=2U
Mr19esd_Mclamp_f18 VDDIO VSS VSS VSS nfet L=0.35U W=2U
Mr19esd_Mclamp_f19 VDDIO VSS VSS VSS nfet L=0.35U W=2U
Xr19esd_Resd PAD$45 PADI_R19 VSS rppd r=294.2 L=2U W=2U
Dr19esd_Dp2 PADI_R19 VDDIO dpantenna A=4P P=8U
Mr19esd_Mn2_f0 PADI_R19 VSS VSS VSS nfet L=0.13U W=1U
Mr19rx_Mi1p_f0 r19rx/M1 PADI_R19 VDDIO VDDIO pfet L=0.13U W=1.25U
Mr19rx_Mi1p_f1 r19rx/M1 PADI_R19 VDDIO VDDIO pfet L=0.13U W=1.25U
Mr19rx_Mi1n_f0 r19rx/M1 PADI_R19 VSS VSS nfet L=0.13U W=0.5U
Mr19rx_Mi1n_f1 r19rx/M1 PADI_R19 VSS VSS nfet L=0.13U W=0.5U
Mr19rx_Mi2p_f0 DOUT$19 r19rx/M1 VDDIO VDDIO pfet L=0.13U W=2U
Mr19rx_Mi2p_f1 DOUT$19 r19rx/M1 VDDIO VDDIO pfet L=0.13U W=2U
Mr19rx_Mi2n_f0 DOUT$19 r19rx/M1 VSS VSS nfet L=0.13U W=1U
Mr19rx_Mi2n_f1 DOUT$19 r19rx/M1 VSS VSS nfet L=0.13U W=1U
Dr20esd_Dp1 PAD$46 VDDIO dpantenna A=100P P=40U
Dr20esd_Dn1 VSS PAD$46 dantenna A=100P P=40U
Mr20esd_Mclamp_f0 VDDIO VSS VSS VSS nfet L=0.35U W=2U
Mr20esd_Mclamp_f1 VDDIO VSS VSS VSS nfet L=0.35U W=2U
Mr20esd_Mclamp_f2 VDDIO VSS VSS VSS nfet L=0.35U W=2U
Mr20esd_Mclamp_f3 VDDIO VSS VSS VSS nfet L=0.35U W=2U
Mr20esd_Mclamp_f4 VDDIO VSS VSS VSS nfet L=0.35U W=2U
Mr20esd_Mclamp_f5 VDDIO VSS VSS VSS nfet L=0.35U W=2U
Mr20esd_Mclamp_f6 VDDIO VSS VSS VSS nfet L=0.35U W=2U
Mr20esd_Mclamp_f7 VDDIO VSS VSS VSS nfet L=0.35U W=2U
Mr20esd_Mclamp_f8 VDDIO VSS VSS VSS nfet L=0.35U W=2U
Mr20esd_Mclamp_f9 VDDIO VSS VSS VSS nfet L=0.35U W=2U
Mr20esd_Mclamp_f10 VDDIO VSS VSS VSS nfet L=0.35U W=2U
Mr20esd_Mclamp_f11 VDDIO VSS VSS VSS nfet L=0.35U W=2U
Mr20esd_Mclamp_f12 VDDIO VSS VSS VSS nfet L=0.35U W=2U
Mr20esd_Mclamp_f13 VDDIO VSS VSS VSS nfet L=0.35U W=2U
Mr20esd_Mclamp_f14 VDDIO VSS VSS VSS nfet L=0.35U W=2U
Mr20esd_Mclamp_f15 VDDIO VSS VSS VSS nfet L=0.35U W=2U
Mr20esd_Mclamp_f16 VDDIO VSS VSS VSS nfet L=0.35U W=2U
Mr20esd_Mclamp_f17 VDDIO VSS VSS VSS nfet L=0.35U W=2U
Mr20esd_Mclamp_f18 VDDIO VSS VSS VSS nfet L=0.35U W=2U
Mr20esd_Mclamp_f19 VDDIO VSS VSS VSS nfet L=0.35U W=2U
Xr20esd_Resd PAD$46 PADI_R20 VSS rppd r=294.2 L=2U W=2U
Dr20esd_Dp2 PADI_R20 VDDIO dpantenna A=4P P=8U
Mr20esd_Mn2_f0 PADI_R20 VSS VSS VSS nfet L=0.13U W=1U
Mr20rx_Mi1p_f0 r20rx/M1 PADI_R20 VDDIO VDDIO pfet L=0.13U W=1.25U
Mr20rx_Mi1p_f1 r20rx/M1 PADI_R20 VDDIO VDDIO pfet L=0.13U W=1.25U
Mr20rx_Mi1n_f0 r20rx/M1 PADI_R20 VSS VSS nfet L=0.13U W=0.5U
Mr20rx_Mi1n_f1 r20rx/M1 PADI_R20 VSS VSS nfet L=0.13U W=0.5U
Mr20rx_Mi2p_f0 DOUT$20 r20rx/M1 VDDIO VDDIO pfet L=0.13U W=2U
Mr20rx_Mi2p_f1 DOUT$20 r20rx/M1 VDDIO VDDIO pfet L=0.13U W=2U
Mr20rx_Mi2n_f0 DOUT$20 r20rx/M1 VSS VSS nfet L=0.13U W=1U
Mr20rx_Mi2n_f1 DOUT$20 r20rx/M1 VSS VSS nfet L=0.13U W=1U
Dr21esd_Dp1 PAD$47 VDDIO dpantenna A=100P P=40U
Dr21esd_Dn1 VSS PAD$47 dantenna A=100P P=40U
Mr21esd_Mclamp_f0 VDDIO VSS VSS VSS nfet L=0.35U W=2U
Mr21esd_Mclamp_f1 VDDIO VSS VSS VSS nfet L=0.35U W=2U
Mr21esd_Mclamp_f2 VDDIO VSS VSS VSS nfet L=0.35U W=2U
Mr21esd_Mclamp_f3 VDDIO VSS VSS VSS nfet L=0.35U W=2U
Mr21esd_Mclamp_f4 VDDIO VSS VSS VSS nfet L=0.35U W=2U
Mr21esd_Mclamp_f5 VDDIO VSS VSS VSS nfet L=0.35U W=2U
Mr21esd_Mclamp_f6 VDDIO VSS VSS VSS nfet L=0.35U W=2U
Mr21esd_Mclamp_f7 VDDIO VSS VSS VSS nfet L=0.35U W=2U
Mr21esd_Mclamp_f8 VDDIO VSS VSS VSS nfet L=0.35U W=2U
Mr21esd_Mclamp_f9 VDDIO VSS VSS VSS nfet L=0.35U W=2U
Mr21esd_Mclamp_f10 VDDIO VSS VSS VSS nfet L=0.35U W=2U
Mr21esd_Mclamp_f11 VDDIO VSS VSS VSS nfet L=0.35U W=2U
Mr21esd_Mclamp_f12 VDDIO VSS VSS VSS nfet L=0.35U W=2U
Mr21esd_Mclamp_f13 VDDIO VSS VSS VSS nfet L=0.35U W=2U
Mr21esd_Mclamp_f14 VDDIO VSS VSS VSS nfet L=0.35U W=2U
Mr21esd_Mclamp_f15 VDDIO VSS VSS VSS nfet L=0.35U W=2U
Mr21esd_Mclamp_f16 VDDIO VSS VSS VSS nfet L=0.35U W=2U
Mr21esd_Mclamp_f17 VDDIO VSS VSS VSS nfet L=0.35U W=2U
Mr21esd_Mclamp_f18 VDDIO VSS VSS VSS nfet L=0.35U W=2U
Mr21esd_Mclamp_f19 VDDIO VSS VSS VSS nfet L=0.35U W=2U
Xr21esd_Resd PAD$47 PADI_R21 VSS rppd r=294.2 L=2U W=2U
Dr21esd_Dp2 PADI_R21 VDDIO dpantenna A=4P P=8U
Mr21esd_Mn2_f0 PADI_R21 VSS VSS VSS nfet L=0.13U W=1U
Mr21rx_Mi1p_f0 r21rx/M1 PADI_R21 VDDIO VDDIO pfet L=0.13U W=1.25U
Mr21rx_Mi1p_f1 r21rx/M1 PADI_R21 VDDIO VDDIO pfet L=0.13U W=1.25U
Mr21rx_Mi1n_f0 r21rx/M1 PADI_R21 VSS VSS nfet L=0.13U W=0.5U
Mr21rx_Mi1n_f1 r21rx/M1 PADI_R21 VSS VSS nfet L=0.13U W=0.5U
Mr21rx_Mi2p_f0 DOUT$21 r21rx/M1 VDDIO VDDIO pfet L=0.13U W=2U
Mr21rx_Mi2p_f1 DOUT$21 r21rx/M1 VDDIO VDDIO pfet L=0.13U W=2U
Mr21rx_Mi2n_f0 DOUT$21 r21rx/M1 VSS VSS nfet L=0.13U W=1U
Mr21rx_Mi2n_f1 DOUT$21 r21rx/M1 VSS VSS nfet L=0.13U W=1U
Dr22esd_Dp1 PAD$25 VDDIO dpantenna A=100P P=40U
Dr22esd_Dn1 VSS PAD$25 dantenna A=100P P=40U
Mr22esd_Mclamp_f0 VDDIO VSS VSS VSS nfet L=0.35U W=2U
Mr22esd_Mclamp_f1 VDDIO VSS VSS VSS nfet L=0.35U W=2U
Mr22esd_Mclamp_f2 VDDIO VSS VSS VSS nfet L=0.35U W=2U
Mr22esd_Mclamp_f3 VDDIO VSS VSS VSS nfet L=0.35U W=2U
Mr22esd_Mclamp_f4 VDDIO VSS VSS VSS nfet L=0.35U W=2U
Mr22esd_Mclamp_f5 VDDIO VSS VSS VSS nfet L=0.35U W=2U
Mr22esd_Mclamp_f6 VDDIO VSS VSS VSS nfet L=0.35U W=2U
Mr22esd_Mclamp_f7 VDDIO VSS VSS VSS nfet L=0.35U W=2U
Mr22esd_Mclamp_f8 VDDIO VSS VSS VSS nfet L=0.35U W=2U
Mr22esd_Mclamp_f9 VDDIO VSS VSS VSS nfet L=0.35U W=2U
Mr22esd_Mclamp_f10 VDDIO VSS VSS VSS nfet L=0.35U W=2U
Mr22esd_Mclamp_f11 VDDIO VSS VSS VSS nfet L=0.35U W=2U
Mr22esd_Mclamp_f12 VDDIO VSS VSS VSS nfet L=0.35U W=2U
Mr22esd_Mclamp_f13 VDDIO VSS VSS VSS nfet L=0.35U W=2U
Mr22esd_Mclamp_f14 VDDIO VSS VSS VSS nfet L=0.35U W=2U
Mr22esd_Mclamp_f15 VDDIO VSS VSS VSS nfet L=0.35U W=2U
Mr22esd_Mclamp_f16 VDDIO VSS VSS VSS nfet L=0.35U W=2U
Mr22esd_Mclamp_f17 VDDIO VSS VSS VSS nfet L=0.35U W=2U
Mr22esd_Mclamp_f18 VDDIO VSS VSS VSS nfet L=0.35U W=2U
Mr22esd_Mclamp_f19 VDDIO VSS VSS VSS nfet L=0.35U W=2U
Xr22esd_Resd PAD$25 PADI_R22 VSS rppd r=294.2 L=2U W=2U
Dr22esd_Dp2 PADI_R22 VDDIO dpantenna A=4P P=8U
Mr22esd_Mn2_f0 PADI_R22 VSS VSS VSS nfet L=0.13U W=1U
Mr22rx_Mi1p_f0 r22rx/M1 PADI_R22 VDDIO VDDIO pfet L=0.13U W=1.25U
Mr22rx_Mi1p_f1 r22rx/M1 PADI_R22 VDDIO VDDIO pfet L=0.13U W=1.25U
Mr22rx_Mi1n_f0 r22rx/M1 PADI_R22 VSS VSS nfet L=0.13U W=0.5U
Mr22rx_Mi1n_f1 r22rx/M1 PADI_R22 VSS VSS nfet L=0.13U W=0.5U
Mr22rx_Mi2p_f0 DOUT$22 r22rx/M1 VDDIO VDDIO pfet L=0.13U W=2U
Mr22rx_Mi2p_f1 DOUT$22 r22rx/M1 VDDIO VDDIO pfet L=0.13U W=2U
Mr22rx_Mi2n_f0 DOUT$22 r22rx/M1 VSS VSS nfet L=0.13U W=1U
Mr22rx_Mi2n_f1 DOUT$22 r22rx/M1 VSS VSS nfet L=0.13U W=1U
Dr23esd_Dp1 PAD$30 VDDIO dpantenna A=100P P=40U
Dr23esd_Dn1 VSS PAD$30 dantenna A=100P P=40U
Mr23esd_Mclamp_f0 VDDIO VSS VSS VSS nfet L=0.35U W=2U
Mr23esd_Mclamp_f1 VDDIO VSS VSS VSS nfet L=0.35U W=2U
Mr23esd_Mclamp_f2 VDDIO VSS VSS VSS nfet L=0.35U W=2U
Mr23esd_Mclamp_f3 VDDIO VSS VSS VSS nfet L=0.35U W=2U
Mr23esd_Mclamp_f4 VDDIO VSS VSS VSS nfet L=0.35U W=2U
Mr23esd_Mclamp_f5 VDDIO VSS VSS VSS nfet L=0.35U W=2U
Mr23esd_Mclamp_f6 VDDIO VSS VSS VSS nfet L=0.35U W=2U
Mr23esd_Mclamp_f7 VDDIO VSS VSS VSS nfet L=0.35U W=2U
Mr23esd_Mclamp_f8 VDDIO VSS VSS VSS nfet L=0.35U W=2U
Mr23esd_Mclamp_f9 VDDIO VSS VSS VSS nfet L=0.35U W=2U
Mr23esd_Mclamp_f10 VDDIO VSS VSS VSS nfet L=0.35U W=2U
Mr23esd_Mclamp_f11 VDDIO VSS VSS VSS nfet L=0.35U W=2U
Mr23esd_Mclamp_f12 VDDIO VSS VSS VSS nfet L=0.35U W=2U
Mr23esd_Mclamp_f13 VDDIO VSS VSS VSS nfet L=0.35U W=2U
Mr23esd_Mclamp_f14 VDDIO VSS VSS VSS nfet L=0.35U W=2U
Mr23esd_Mclamp_f15 VDDIO VSS VSS VSS nfet L=0.35U W=2U
Mr23esd_Mclamp_f16 VDDIO VSS VSS VSS nfet L=0.35U W=2U
Mr23esd_Mclamp_f17 VDDIO VSS VSS VSS nfet L=0.35U W=2U
Mr23esd_Mclamp_f18 VDDIO VSS VSS VSS nfet L=0.35U W=2U
Mr23esd_Mclamp_f19 VDDIO VSS VSS VSS nfet L=0.35U W=2U
Xr23esd_Resd PAD$30 PADI_R23 VSS rppd r=294.2 L=2U W=2U
Dr23esd_Dp2 PADI_R23 VDDIO dpantenna A=4P P=8U
Mr23esd_Mn2_f0 PADI_R23 VSS VSS VSS nfet L=0.13U W=1U
Mr23rx_Mi1p_f0 r23rx/M1 PADI_R23 VDDIO VDDIO pfet L=0.13U W=1.25U
Mr23rx_Mi1p_f1 r23rx/M1 PADI_R23 VDDIO VDDIO pfet L=0.13U W=1.25U
Mr23rx_Mi1n_f0 r23rx/M1 PADI_R23 VSS VSS nfet L=0.13U W=0.5U
Mr23rx_Mi1n_f1 r23rx/M1 PADI_R23 VSS VSS nfet L=0.13U W=0.5U
Mr23rx_Mi2p_f0 DOUT$23 r23rx/M1 VDDIO VDDIO pfet L=0.13U W=2U
Mr23rx_Mi2p_f1 DOUT$23 r23rx/M1 VDDIO VDDIO pfet L=0.13U W=2U
Mr23rx_Mi2n_f0 DOUT$23 r23rx/M1 VSS VSS nfet L=0.13U W=1U
Mr23rx_Mi2n_f1 DOUT$23 r23rx/M1 VSS VSS nfet L=0.13U W=1U
.ENDS
