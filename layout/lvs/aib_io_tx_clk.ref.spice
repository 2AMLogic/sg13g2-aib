* Generated by layout/lvs/gen_reference.py -- DO NOT EDIT BY HAND.
* Plain-element form for `klt lvs`; flattened from the item 1 netlists:
*   design/aib_pad_esd.spice sha256:86d410385d099254f0376b9b4638cd18dfee8e7ae538a45e2ed85e2cdea415d5
*   design/aib_tx_data.spice sha256:adf7d751f8645148fe68be97b8d1ade38a2eadbf5432e05eed059c570850d2d7
*   design/aib_rx_data.spice sha256:43f326de980bc5a817d6235ab5402de4aa02886619ead25e7e60c41dfef99eab
*   design/aib_tx_clk.spice sha256:d2bdf119e914678106c566674093ccc54b75174d76592851cfd98db57dce32ad
*   design/aib_rx_clk.spice sha256:0e53de36f4d0d2585452746bb2cb5d35e7c8b0801cdf597efe1dbb7bc01b5b2d
.SUBCKT aib_io_tx_clk DIN DIN$1 OE PAD PAD$1 PD PUN VDDIO VSS
Daesd_Dp1 PAD VDDIO dpantenna A=100P P=40U
Daesd_Dn1 VSS PAD dantenna A=100P P=40U
Maesd_Mclamp_f0 VDDIO VSS VSS VSS nfet L=0.35U W=2U
Maesd_Mclamp_f1 VDDIO VSS VSS VSS nfet L=0.35U W=2U
Maesd_Mclamp_f2 VDDIO VSS VSS VSS nfet L=0.35U W=2U
Maesd_Mclamp_f3 VDDIO VSS VSS VSS nfet L=0.35U W=2U
Maesd_Mclamp_f4 VDDIO VSS VSS VSS nfet L=0.35U W=2U
Maesd_Mclamp_f5 VDDIO VSS VSS VSS nfet L=0.35U W=2U
Maesd_Mclamp_f6 VDDIO VSS VSS VSS nfet L=0.35U W=2U
Maesd_Mclamp_f7 VDDIO VSS VSS VSS nfet L=0.35U W=2U
Maesd_Mclamp_f8 VDDIO VSS VSS VSS nfet L=0.35U W=2U
Maesd_Mclamp_f9 VDDIO VSS VSS VSS nfet L=0.35U W=2U
Maesd_Mclamp_f10 VDDIO VSS VSS VSS nfet L=0.35U W=2U
Maesd_Mclamp_f11 VDDIO VSS VSS VSS nfet L=0.35U W=2U
Maesd_Mclamp_f12 VDDIO VSS VSS VSS nfet L=0.35U W=2U
Maesd_Mclamp_f13 VDDIO VSS VSS VSS nfet L=0.35U W=2U
Maesd_Mclamp_f14 VDDIO VSS VSS VSS nfet L=0.35U W=2U
Maesd_Mclamp_f15 VDDIO VSS VSS VSS nfet L=0.35U W=2U
Maesd_Mclamp_f16 VDDIO VSS VSS VSS nfet L=0.35U W=2U
Maesd_Mclamp_f17 VDDIO VSS VSS VSS nfet L=0.35U W=2U
Maesd_Mclamp_f18 VDDIO VSS VSS VSS nfet L=0.35U W=2U
Maesd_Mclamp_f19 VDDIO VSS VSS VSS nfet L=0.35U W=2U
Xaesd_Resd PAD PADI_A VSS rppd r=294.2 L=2U W=2U
Daesd_Dp2 PADI_A VDDIO dpantenna A=4P P=8U
Maesd_Mn2_f0 PADI_A VSS VSS VSS nfet L=0.13U W=1U
Matx_Mi1p_f0 atx/OEB OE VDDIO VDDIO pfet L=0.13U W=2U
Matx_Mi1n_f0 atx/OEB OE VSS VSS nfet L=0.13U W=1U
Matx_Mnd1p_f0 atx/GP DIN VDDIO VDDIO pfet L=0.13U W=2U
Matx_Mnd1p_f1 atx/GP DIN VDDIO VDDIO pfet L=0.13U W=2U
Matx_Mnd2p_f0 atx/GP OE VDDIO VDDIO pfet L=0.13U W=2U
Matx_Mnd2p_f1 atx/GP OE VDDIO VDDIO pfet L=0.13U W=2U
Matx_Mnd1n_f0 atx/GP DIN atx/NA VSS nfet L=0.13U W=2U
Matx_Mnd1n_f1 atx/GP DIN atx/NA VSS nfet L=0.13U W=2U
Matx_Mnd2n_f0 atx/NA OE VSS VSS nfet L=0.13U W=2U
Matx_Mnd2n_f1 atx/NA OE VSS VSS nfet L=0.13U W=2U
Matx_Mnr1p_f0 atx/NB DIN VDDIO VDDIO pfet L=0.13U W=2U
Matx_Mnr1p_f1 atx/NB DIN VDDIO VDDIO pfet L=0.13U W=2U
Matx_Mnr2p_f0 atx/GN atx/OEB atx/NB VDDIO pfet L=0.13U W=2U
Matx_Mnr2p_f1 atx/GN atx/OEB atx/NB VDDIO pfet L=0.13U W=2U
Matx_Mnr1n_f0 atx/GN DIN VSS VSS nfet L=0.13U W=1U
Matx_Mnr1n_f1 atx/GN DIN VSS VSS nfet L=0.13U W=1U
Matx_Mnr2n_f0 atx/GN atx/OEB VSS VSS nfet L=0.13U W=1U
Matx_Mnr2n_f1 atx/GN atx/OEB VSS VSS nfet L=0.13U W=1U
Matx_Mp_f0 PAD atx/GP VDDIO VDDIO pfet L=0.13U W=1U
Matx_Mp_f1 PAD atx/GP VDDIO VDDIO pfet L=0.13U W=1U
Matx_Mp_f2 PAD atx/GP VDDIO VDDIO pfet L=0.13U W=1U
Matx_Mp_f3 PAD atx/GP VDDIO VDDIO pfet L=0.13U W=1U
Matx_Mp_f4 PAD atx/GP VDDIO VDDIO pfet L=0.13U W=1U
Matx_Mp_f5 PAD atx/GP VDDIO VDDIO pfet L=0.13U W=1U
Matx_Mp_f6 PAD atx/GP VDDIO VDDIO pfet L=0.13U W=1U
Matx_Mp_f7 PAD atx/GP VDDIO VDDIO pfet L=0.13U W=1U
Matx_Mp_f8 PAD atx/GP VDDIO VDDIO pfet L=0.13U W=1U
Matx_Mp_f9 PAD atx/GP VDDIO VDDIO pfet L=0.13U W=1U
Matx_Mp_f10 PAD atx/GP VDDIO VDDIO pfet L=0.13U W=1U
Matx_Mp_f11 PAD atx/GP VDDIO VDDIO pfet L=0.13U W=1U
Matx_Mp_f12 PAD atx/GP VDDIO VDDIO pfet L=0.13U W=1U
Matx_Mp_f13 PAD atx/GP VDDIO VDDIO pfet L=0.13U W=1U
Matx_Mp_f14 PAD atx/GP VDDIO VDDIO pfet L=0.13U W=1U
Matx_Mp_f15 PAD atx/GP VDDIO VDDIO pfet L=0.13U W=1U
Matx_Mp_f16 PAD atx/GP VDDIO VDDIO pfet L=0.13U W=1U
Matx_Mp_f17 PAD atx/GP VDDIO VDDIO pfet L=0.13U W=1U
Matx_Mp_f18 PAD atx/GP VDDIO VDDIO pfet L=0.13U W=1U
Matx_Mp_f19 PAD atx/GP VDDIO VDDIO pfet L=0.13U W=1U
Matx_Mp_f20 PAD atx/GP VDDIO VDDIO pfet L=0.13U W=1U
Matx_Mp_f21 PAD atx/GP VDDIO VDDIO pfet L=0.13U W=1U
Matx_Mp_f22 PAD atx/GP VDDIO VDDIO pfet L=0.13U W=1U
Matx_Mp_f23 PAD atx/GP VDDIO VDDIO pfet L=0.13U W=1U
Matx_Mp_f24 PAD atx/GP VDDIO VDDIO pfet L=0.13U W=1U
Matx_Mp_f25 PAD atx/GP VDDIO VDDIO pfet L=0.13U W=1U
Matx_Mp_f26 PAD atx/GP VDDIO VDDIO pfet L=0.13U W=1U
Matx_Mp_f27 PAD atx/GP VDDIO VDDIO pfet L=0.13U W=1U
Matx_Mn_f0 PAD atx/GN VSS VSS nfet L=0.13U W=1U
Matx_Mn_f1 PAD atx/GN VSS VSS nfet L=0.13U W=1U
Matx_Mn_f2 PAD atx/GN VSS VSS nfet L=0.13U W=1U
Matx_Mn_f3 PAD atx/GN VSS VSS nfet L=0.13U W=1U
Matx_Mn_f4 PAD atx/GN VSS VSS nfet L=0.13U W=1U
Matx_Mn_f5 PAD atx/GN VSS VSS nfet L=0.13U W=1U
Matx_Mn_f6 PAD atx/GN VSS VSS nfet L=0.13U W=1U
Matx_Mn_f7 PAD atx/GN VSS VSS nfet L=0.13U W=1U
Matx_Mn_f8 PAD atx/GN VSS VSS nfet L=0.13U W=1U
Matx_Mn_f9 PAD atx/GN VSS VSS nfet L=0.13U W=1U
Matx_Mn_f10 PAD atx/GN VSS VSS nfet L=0.13U W=1U
Matx_Mn_f11 PAD atx/GN VSS VSS nfet L=0.13U W=1U
Matx_Mn_f12 PAD atx/GN VSS VSS nfet L=0.13U W=1U
Matx_Mn_f13 PAD atx/GN VSS VSS nfet L=0.13U W=1U
Matx_Mpu_f0 atx/PUX PUN VDDIO VDDIO pfet L=0.13U W=2U
Xatx_Rpu atx/PUX PAD VSS rppd r=12472.0 L=24U W=0.5U
Matx_Mpd_f0 atx/PDX PD VSS VSS nfet L=0.13U W=1U
Xatx_Rpd PAD atx/PDX VSS rppd r=12472.0 L=24U W=0.5U
Dbesd_Dp1 PAD$1 VDDIO dpantenna A=100P P=40U
Dbesd_Dn1 VSS PAD$1 dantenna A=100P P=40U
Mbesd_Mclamp_f0 VDDIO VSS VSS VSS nfet L=0.35U W=2U
Mbesd_Mclamp_f1 VDDIO VSS VSS VSS nfet L=0.35U W=2U
Mbesd_Mclamp_f2 VDDIO VSS VSS VSS nfet L=0.35U W=2U
Mbesd_Mclamp_f3 VDDIO VSS VSS VSS nfet L=0.35U W=2U
Mbesd_Mclamp_f4 VDDIO VSS VSS VSS nfet L=0.35U W=2U
Mbesd_Mclamp_f5 VDDIO VSS VSS VSS nfet L=0.35U W=2U
Mbesd_Mclamp_f6 VDDIO VSS VSS VSS nfet L=0.35U W=2U
Mbesd_Mclamp_f7 VDDIO VSS VSS VSS nfet L=0.35U W=2U
Mbesd_Mclamp_f8 VDDIO VSS VSS VSS nfet L=0.35U W=2U
Mbesd_Mclamp_f9 VDDIO VSS VSS VSS nfet L=0.35U W=2U
Mbesd_Mclamp_f10 VDDIO VSS VSS VSS nfet L=0.35U W=2U
Mbesd_Mclamp_f11 VDDIO VSS VSS VSS nfet L=0.35U W=2U
Mbesd_Mclamp_f12 VDDIO VSS VSS VSS nfet L=0.35U W=2U
Mbesd_Mclamp_f13 VDDIO VSS VSS VSS nfet L=0.35U W=2U
Mbesd_Mclamp_f14 VDDIO VSS VSS VSS nfet L=0.35U W=2U
Mbesd_Mclamp_f15 VDDIO VSS VSS VSS nfet L=0.35U W=2U
Mbesd_Mclamp_f16 VDDIO VSS VSS VSS nfet L=0.35U W=2U
Mbesd_Mclamp_f17 VDDIO VSS VSS VSS nfet L=0.35U W=2U
Mbesd_Mclamp_f18 VDDIO VSS VSS VSS nfet L=0.35U W=2U
Mbesd_Mclamp_f19 VDDIO VSS VSS VSS nfet L=0.35U W=2U
Xbesd_Resd PAD$1 PADI_B VSS rppd r=294.2 L=2U W=2U
Dbesd_Dp2 PADI_B VDDIO dpantenna A=4P P=8U
Mbesd_Mn2_f0 PADI_B VSS VSS VSS nfet L=0.13U W=1U
Mbtx_Mi1p_f0 btx/OEB OE VDDIO VDDIO pfet L=0.13U W=2U
Mbtx_Mi1n_f0 btx/OEB OE VSS VSS nfet L=0.13U W=1U
Mbtx_Mnd1p_f0 btx/GP DIN$1 VDDIO VDDIO pfet L=0.13U W=2U
Mbtx_Mnd1p_f1 btx/GP DIN$1 VDDIO VDDIO pfet L=0.13U W=2U
Mbtx_Mnd2p_f0 btx/GP OE VDDIO VDDIO pfet L=0.13U W=2U
Mbtx_Mnd2p_f1 btx/GP OE VDDIO VDDIO pfet L=0.13U W=2U
Mbtx_Mnd1n_f0 btx/GP DIN$1 btx/NA VSS nfet L=0.13U W=2U
Mbtx_Mnd1n_f1 btx/GP DIN$1 btx/NA VSS nfet L=0.13U W=2U
Mbtx_Mnd2n_f0 btx/NA OE VSS VSS nfet L=0.13U W=2U
Mbtx_Mnd2n_f1 btx/NA OE VSS VSS nfet L=0.13U W=2U
Mbtx_Mnr1p_f0 btx/NB DIN$1 VDDIO VDDIO pfet L=0.13U W=2U
Mbtx_Mnr1p_f1 btx/NB DIN$1 VDDIO VDDIO pfet L=0.13U W=2U
Mbtx_Mnr2p_f0 btx/GN btx/OEB btx/NB VDDIO pfet L=0.13U W=2U
Mbtx_Mnr2p_f1 btx/GN btx/OEB btx/NB VDDIO pfet L=0.13U W=2U
Mbtx_Mnr1n_f0 btx/GN DIN$1 VSS VSS nfet L=0.13U W=1U
Mbtx_Mnr1n_f1 btx/GN DIN$1 VSS VSS nfet L=0.13U W=1U
Mbtx_Mnr2n_f0 btx/GN btx/OEB VSS VSS nfet L=0.13U W=1U
Mbtx_Mnr2n_f1 btx/GN btx/OEB VSS VSS nfet L=0.13U W=1U
Mbtx_Mp_f0 PAD$1 btx/GP VDDIO VDDIO pfet L=0.13U W=1U
Mbtx_Mp_f1 PAD$1 btx/GP VDDIO VDDIO pfet L=0.13U W=1U
Mbtx_Mp_f2 PAD$1 btx/GP VDDIO VDDIO pfet L=0.13U W=1U
Mbtx_Mp_f3 PAD$1 btx/GP VDDIO VDDIO pfet L=0.13U W=1U
Mbtx_Mp_f4 PAD$1 btx/GP VDDIO VDDIO pfet L=0.13U W=1U
Mbtx_Mp_f5 PAD$1 btx/GP VDDIO VDDIO pfet L=0.13U W=1U
Mbtx_Mp_f6 PAD$1 btx/GP VDDIO VDDIO pfet L=0.13U W=1U
Mbtx_Mp_f7 PAD$1 btx/GP VDDIO VDDIO pfet L=0.13U W=1U
Mbtx_Mp_f8 PAD$1 btx/GP VDDIO VDDIO pfet L=0.13U W=1U
Mbtx_Mp_f9 PAD$1 btx/GP VDDIO VDDIO pfet L=0.13U W=1U
Mbtx_Mp_f10 PAD$1 btx/GP VDDIO VDDIO pfet L=0.13U W=1U
Mbtx_Mp_f11 PAD$1 btx/GP VDDIO VDDIO pfet L=0.13U W=1U
Mbtx_Mp_f12 PAD$1 btx/GP VDDIO VDDIO pfet L=0.13U W=1U
Mbtx_Mp_f13 PAD$1 btx/GP VDDIO VDDIO pfet L=0.13U W=1U
Mbtx_Mp_f14 PAD$1 btx/GP VDDIO VDDIO pfet L=0.13U W=1U
Mbtx_Mp_f15 PAD$1 btx/GP VDDIO VDDIO pfet L=0.13U W=1U
Mbtx_Mp_f16 PAD$1 btx/GP VDDIO VDDIO pfet L=0.13U W=1U
Mbtx_Mp_f17 PAD$1 btx/GP VDDIO VDDIO pfet L=0.13U W=1U
Mbtx_Mp_f18 PAD$1 btx/GP VDDIO VDDIO pfet L=0.13U W=1U
Mbtx_Mp_f19 PAD$1 btx/GP VDDIO VDDIO pfet L=0.13U W=1U
Mbtx_Mp_f20 PAD$1 btx/GP VDDIO VDDIO pfet L=0.13U W=1U
Mbtx_Mp_f21 PAD$1 btx/GP VDDIO VDDIO pfet L=0.13U W=1U
Mbtx_Mp_f22 PAD$1 btx/GP VDDIO VDDIO pfet L=0.13U W=1U
Mbtx_Mp_f23 PAD$1 btx/GP VDDIO VDDIO pfet L=0.13U W=1U
Mbtx_Mp_f24 PAD$1 btx/GP VDDIO VDDIO pfet L=0.13U W=1U
Mbtx_Mp_f25 PAD$1 btx/GP VDDIO VDDIO pfet L=0.13U W=1U
Mbtx_Mp_f26 PAD$1 btx/GP VDDIO VDDIO pfet L=0.13U W=1U
Mbtx_Mp_f27 PAD$1 btx/GP VDDIO VDDIO pfet L=0.13U W=1U
Mbtx_Mn_f0 PAD$1 btx/GN VSS VSS nfet L=0.13U W=1U
Mbtx_Mn_f1 PAD$1 btx/GN VSS VSS nfet L=0.13U W=1U
Mbtx_Mn_f2 PAD$1 btx/GN VSS VSS nfet L=0.13U W=1U
Mbtx_Mn_f3 PAD$1 btx/GN VSS VSS nfet L=0.13U W=1U
Mbtx_Mn_f4 PAD$1 btx/GN VSS VSS nfet L=0.13U W=1U
Mbtx_Mn_f5 PAD$1 btx/GN VSS VSS nfet L=0.13U W=1U
Mbtx_Mn_f6 PAD$1 btx/GN VSS VSS nfet L=0.13U W=1U
Mbtx_Mn_f7 PAD$1 btx/GN VSS VSS nfet L=0.13U W=1U
Mbtx_Mn_f8 PAD$1 btx/GN VSS VSS nfet L=0.13U W=1U
Mbtx_Mn_f9 PAD$1 btx/GN VSS VSS nfet L=0.13U W=1U
Mbtx_Mn_f10 PAD$1 btx/GN VSS VSS nfet L=0.13U W=1U
Mbtx_Mn_f11 PAD$1 btx/GN VSS VSS nfet L=0.13U W=1U
Mbtx_Mn_f12 PAD$1 btx/GN VSS VSS nfet L=0.13U W=1U
Mbtx_Mn_f13 PAD$1 btx/GN VSS VSS nfet L=0.13U W=1U
Mbtx_Mpu_f0 btx/PUX PUN VDDIO VDDIO pfet L=0.13U W=2U
Xbtx_Rpu btx/PUX PAD$1 VSS rppd r=12472.0 L=24U W=0.5U
Mbtx_Mpd_f0 btx/PDX PD VSS VSS nfet L=0.13U W=1U
Xbtx_Rpd PAD$1 btx/PDX VSS rppd r=12472.0 L=24U W=0.5U
.ENDS
