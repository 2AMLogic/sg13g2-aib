* Generated by layout/lvs/gen_reference.py -- DO NOT EDIT BY HAND.
* Plain-element form for `klt lvs`; flattened from the item 1 netlists:
*   design/aib_pad_esd.spice sha256:78e223623f816e37dcb6735de42bb35d93675dd5a8c023ab0a56b1d864d3c83e
*   design/aib_tx_data.spice sha256:c24baff6ba4ce141d2c587bd1581746be8b3ccf1c10f5209a0ea8937446f945d
*   design/aib_rx_data.spice sha256:43f326de980bc5a817d6235ab5402de4aa02886619ead25e7e60c41dfef99eab
*   design/aib_tx_clk.spice sha256:a1b8b12ee92fcbcb4746868f2f21ef8c5dc437fd33854036039468095f474cdd
*   design/aib_rx_clk.spice sha256:0e53de36f4d0d2585452746bb2cb5d35e7c8b0801cdf597efe1dbb7bc01b5b2d
.SUBCKT aib_io_tx_clk DIN DIN$1 OE PAD PAD$1 PD PUN VDDIO VSS
Daesd_Dp1 PAD VDDIO dpantenna A=20.25P P=18U
Maesd_Mn1_f0 PAD VSS VSS VSS nfet L=0.13U W=2U
Maesd_Mn1_f1 PAD VSS VSS VSS nfet L=0.13U W=2U
Maesd_Mn1_f2 PAD VSS VSS VSS nfet L=0.13U W=2U
Maesd_Mn1_f3 PAD VSS VSS VSS nfet L=0.13U W=2U
Maesd_Mn1_f4 PAD VSS VSS VSS nfet L=0.13U W=2U
Maesd_Mn1_f5 PAD VSS VSS VSS nfet L=0.13U W=2U
Maesd_Mn1_f6 PAD VSS VSS VSS nfet L=0.13U W=2U
Maesd_Mn1_f7 PAD VSS VSS VSS nfet L=0.13U W=2U
Maesd_Mn1_f8 PAD VSS VSS VSS nfet L=0.13U W=2U
Maesd_Mn1_f9 PAD VSS VSS VSS nfet L=0.13U W=2U
Maesd_Mclamp_f0 VDDIO VSS VSS VSS nfet L=0.35U W=2U
Maesd_Mclamp_f1 VDDIO VSS VSS VSS nfet L=0.35U W=2U
Maesd_Mclamp_f2 VDDIO VSS VSS VSS nfet L=0.35U W=2U
Maesd_Mclamp_f3 VDDIO VSS VSS VSS nfet L=0.35U W=2U
Maesd_Mclamp_f4 VDDIO VSS VSS VSS nfet L=0.35U W=2U
Maesd_Mclamp_f5 VDDIO VSS VSS VSS nfet L=0.35U W=2U
Maesd_Mclamp_f6 VDDIO VSS VSS VSS nfet L=0.35U W=2U
Maesd_Mclamp_f7 VDDIO VSS VSS VSS nfet L=0.35U W=2U
Maesd_Mclamp_f8 VDDIO VSS VSS VSS nfet L=0.35U W=2U
Maesd_Mclamp_f9 VDDIO VSS VSS VSS nfet L=0.35U W=2U
Maesd_Mclamp_f10 VDDIO VSS VSS VSS nfet L=0.35U W=2U
Maesd_Mclamp_f11 VDDIO VSS VSS VSS nfet L=0.35U W=2U
Maesd_Mclamp_f12 VDDIO VSS VSS VSS nfet L=0.35U W=2U
Maesd_Mclamp_f13 VDDIO VSS VSS VSS nfet L=0.35U W=2U
Maesd_Mclamp_f14 VDDIO VSS VSS VSS nfet L=0.35U W=2U
Maesd_Mclamp_f15 VDDIO VSS VSS VSS nfet L=0.35U W=2U
Maesd_Mclamp_f16 VDDIO VSS VSS VSS nfet L=0.35U W=2U
Maesd_Mclamp_f17 VDDIO VSS VSS VSS nfet L=0.35U W=2U
Maesd_Mclamp_f18 VDDIO VSS VSS VSS nfet L=0.35U W=2U
Maesd_Mclamp_f19 VDDIO VSS VSS VSS nfet L=0.35U W=2U
Xaesd_Resd PAD PADI_A VSS rppd r=294.2 L=2U W=2U
Daesd_Dp2 PADI_A VDDIO dpantenna A=4P P=8U
Maesd_Mn2_f0 PADI_A VSS VSS VSS nfet L=0.13U W=1U
Matx_Mi1p_f0 atx/OEB OE VDDIO VDDIO pfet L=0.13U W=2U
Matx_Mi1n_f0 atx/OEB OE VSS VSS nfet L=0.13U W=1U
Matx_Mnd1p_f0 atx/GP DIN$1 VDDIO VDDIO pfet L=0.13U W=2U
Matx_Mnd1p_f1 atx/GP DIN$1 VDDIO VDDIO pfet L=0.13U W=2U
Matx_Mnd2p_f0 atx/GP OE VDDIO VDDIO pfet L=0.13U W=2U
Matx_Mnd2p_f1 atx/GP OE VDDIO VDDIO pfet L=0.13U W=2U
Matx_Mnd1n_f0 atx/GP DIN$1 atx/NA VSS nfet L=0.13U W=2U
Matx_Mnd1n_f1 atx/GP DIN$1 atx/NA VSS nfet L=0.13U W=2U
Matx_Mnd2n_f0 atx/NA OE VSS VSS nfet L=0.13U W=2U
Matx_Mnd2n_f1 atx/NA OE VSS VSS nfet L=0.13U W=2U
Matx_Mnr1p_f0 atx/NB DIN$1 VDDIO VDDIO pfet L=0.13U W=2U
Matx_Mnr1p_f1 atx/NB DIN$1 VDDIO VDDIO pfet L=0.13U W=2U
Matx_Mnr2p_f0 atx/GN atx/OEB atx/NB VDDIO pfet L=0.13U W=2U
Matx_Mnr2p_f1 atx/GN atx/OEB atx/NB VDDIO pfet L=0.13U W=2U
Matx_Mnr1n_f0 atx/GN DIN$1 VSS VSS nfet L=0.13U W=1U
Matx_Mnr1n_f1 atx/GN DIN$1 VSS VSS nfet L=0.13U W=1U
Matx_Mnr2n_f0 atx/GN atx/OEB VSS VSS nfet L=0.13U W=1U
Matx_Mnr2n_f1 atx/GN atx/OEB VSS VSS nfet L=0.13U W=1U
Matx_Mp_f0 atx/DP atx/GP VDDIO VDDIO pfet L=0.13U W=1U
Matx_Mp_f1 atx/DP atx/GP VDDIO VDDIO pfet L=0.13U W=1U
Matx_Mp_f2 atx/DP atx/GP VDDIO VDDIO pfet L=0.13U W=1U
Matx_Mp_f3 atx/DP atx/GP VDDIO VDDIO pfet L=0.13U W=1U
Matx_Mp_f4 atx/DP atx/GP VDDIO VDDIO pfet L=0.13U W=1U
Matx_Mp_f5 atx/DP atx/GP VDDIO VDDIO pfet L=0.13U W=1U
Matx_Mp_f6 atx/DP atx/GP VDDIO VDDIO pfet L=0.13U W=1U
Matx_Mp_f7 atx/DP atx/GP VDDIO VDDIO pfet L=0.13U W=1U
Matx_Mp_f8 atx/DP atx/GP VDDIO VDDIO pfet L=0.13U W=1U
Matx_Mp_f9 atx/DP atx/GP VDDIO VDDIO pfet L=0.13U W=1U
Matx_Mp_f10 atx/DP atx/GP VDDIO VDDIO pfet L=0.13U W=1U
Matx_Mp_f11 atx/DP atx/GP VDDIO VDDIO pfet L=0.13U W=1U
Matx_Mp_f12 atx/DP atx/GP VDDIO VDDIO pfet L=0.13U W=1U
Matx_Mp_f13 atx/DP atx/GP VDDIO VDDIO pfet L=0.13U W=1U
Matx_Mp_f14 atx/DP atx/GP VDDIO VDDIO pfet L=0.13U W=1U
Matx_Mp_f15 atx/DP atx/GP VDDIO VDDIO pfet L=0.13U W=1U
Matx_Mp_f16 atx/DP atx/GP VDDIO VDDIO pfet L=0.13U W=1U
Matx_Mp_f17 atx/DP atx/GP VDDIO VDDIO pfet L=0.13U W=1U
Matx_Mp_f18 atx/DP atx/GP VDDIO VDDIO pfet L=0.13U W=1U
Matx_Mp_f19 atx/DP atx/GP VDDIO VDDIO pfet L=0.13U W=1U
Matx_Mp_f20 atx/DP atx/GP VDDIO VDDIO pfet L=0.13U W=1U
Matx_Mp_f21 atx/DP atx/GP VDDIO VDDIO pfet L=0.13U W=1U
Matx_Mp_f22 atx/DP atx/GP VDDIO VDDIO pfet L=0.13U W=1U
Matx_Mp_f23 atx/DP atx/GP VDDIO VDDIO pfet L=0.13U W=1U
Matx_Mp_f24 atx/DP atx/GP VDDIO VDDIO pfet L=0.13U W=1U
Matx_Mp_f25 atx/DP atx/GP VDDIO VDDIO pfet L=0.13U W=1U
Matx_Mp_f26 atx/DP atx/GP VDDIO VDDIO pfet L=0.13U W=1U
Matx_Mp_f27 atx/DP atx/GP VDDIO VDDIO pfet L=0.13U W=1U
Matx_Mp_f28 atx/DP atx/GP VDDIO VDDIO pfet L=0.13U W=1U
Matx_Mp_f29 atx/DP atx/GP VDDIO VDDIO pfet L=0.13U W=1U
Matx_Mp_f30 atx/DP atx/GP VDDIO VDDIO pfet L=0.13U W=1U
Matx_Mp_f31 atx/DP atx/GP VDDIO VDDIO pfet L=0.13U W=1U
Matx_Mp_f32 atx/DP atx/GP VDDIO VDDIO pfet L=0.13U W=1U
Matx_Mp_f33 atx/DP atx/GP VDDIO VDDIO pfet L=0.13U W=1U
Matx_Mp_f34 atx/DP atx/GP VDDIO VDDIO pfet L=0.13U W=1U
Matx_Mp_f35 atx/DP atx/GP VDDIO VDDIO pfet L=0.13U W=1U
Matx_Mp_f36 atx/DP atx/GP VDDIO VDDIO pfet L=0.13U W=1U
Matx_Mp_f37 atx/DP atx/GP VDDIO VDDIO pfet L=0.13U W=1U
Matx_Mp_f38 atx/DP atx/GP VDDIO VDDIO pfet L=0.13U W=1U
Matx_Mp_f39 atx/DP atx/GP VDDIO VDDIO pfet L=0.13U W=1U
Matx_Mp_f40 atx/DP atx/GP VDDIO VDDIO pfet L=0.13U W=1U
Matx_Mp_f41 atx/DP atx/GP VDDIO VDDIO pfet L=0.13U W=1U
Matx_Mp_f42 atx/DP atx/GP VDDIO VDDIO pfet L=0.13U W=1U
Matx_Mp_f43 atx/DP atx/GP VDDIO VDDIO pfet L=0.13U W=1U
Matx_Mp_f44 atx/DP atx/GP VDDIO VDDIO pfet L=0.13U W=1U
Matx_Mp_f45 atx/DP atx/GP VDDIO VDDIO pfet L=0.13U W=1U
Matx_Mp_f46 atx/DP atx/GP VDDIO VDDIO pfet L=0.13U W=1U
Matx_Mp_f47 atx/DP atx/GP VDDIO VDDIO pfet L=0.13U W=1U
Matx_Mp_f48 atx/DP atx/GP VDDIO VDDIO pfet L=0.13U W=1U
Matx_Mp_f49 atx/DP atx/GP VDDIO VDDIO pfet L=0.13U W=1U
Matx_Mp_f50 atx/DP atx/GP VDDIO VDDIO pfet L=0.13U W=1U
Matx_Mp_f51 atx/DP atx/GP VDDIO VDDIO pfet L=0.13U W=1U
Matx_Mp_f52 atx/DP atx/GP VDDIO VDDIO pfet L=0.13U W=1U
Matx_Mp_f53 atx/DP atx/GP VDDIO VDDIO pfet L=0.13U W=1U
Matx_Mn_f0 atx/DN atx/GN VSS VSS nfet L=0.13U W=1U
Matx_Mn_f1 atx/DN atx/GN VSS VSS nfet L=0.13U W=1U
Matx_Mn_f2 atx/DN atx/GN VSS VSS nfet L=0.13U W=1U
Matx_Mn_f3 atx/DN atx/GN VSS VSS nfet L=0.13U W=1U
Matx_Mn_f4 atx/DN atx/GN VSS VSS nfet L=0.13U W=1U
Matx_Mn_f5 atx/DN atx/GN VSS VSS nfet L=0.13U W=1U
Matx_Mn_f6 atx/DN atx/GN VSS VSS nfet L=0.13U W=1U
Matx_Mn_f7 atx/DN atx/GN VSS VSS nfet L=0.13U W=1U
Matx_Mn_f8 atx/DN atx/GN VSS VSS nfet L=0.13U W=1U
Matx_Mn_f9 atx/DN atx/GN VSS VSS nfet L=0.13U W=1U
Matx_Mn_f10 atx/DN atx/GN VSS VSS nfet L=0.13U W=1U
Matx_Mn_f11 atx/DN atx/GN VSS VSS nfet L=0.13U W=1U
Matx_Mn_f12 atx/DN atx/GN VSS VSS nfet L=0.13U W=1U
Matx_Mn_f13 atx/DN atx/GN VSS VSS nfet L=0.13U W=1U
Matx_Mn_f14 atx/DN atx/GN VSS VSS nfet L=0.13U W=1U
Matx_Mn_f15 atx/DN atx/GN VSS VSS nfet L=0.13U W=1U
Matx_Mn_f16 atx/DN atx/GN VSS VSS nfet L=0.13U W=1U
Matx_Mn_f17 atx/DN atx/GN VSS VSS nfet L=0.13U W=1U
Matx_Mn_f18 atx/DN atx/GN VSS VSS nfet L=0.13U W=1U
Matx_Mn_f19 atx/DN atx/GN VSS VSS nfet L=0.13U W=1U
Matx_Mn_f20 atx/DN atx/GN VSS VSS nfet L=0.13U W=1U
Matx_Mn_f21 atx/DN atx/GN VSS VSS nfet L=0.13U W=1U
Matx_Mpu_f0 atx/PUX PUN VDDIO VDDIO pfet L=0.13U W=2U
Xatx_Rpu atx/PUX PAD VSS rppd r=12472.0 L=24U W=0.5U
Matx_Mpd_f0 atx/PDX PD VSS VSS nfet L=0.13U W=1U
Xatx_Rpd PAD atx/PDX VSS rppd r=12472.0 L=24U W=0.5U
Xatx_Rsp atx/DP PAD VSS rppd r=20.0 L=0.5U W=10U
Xatx_Rsn atx/DN PAD VSS rppd r=20.0 L=0.5U W=10U
Dbesd_Dp1 PAD$1 VDDIO dpantenna A=20.25P P=18U
Mbesd_Mn1_f0 PAD$1 VSS VSS VSS nfet L=0.13U W=2U
Mbesd_Mn1_f1 PAD$1 VSS VSS VSS nfet L=0.13U W=2U
Mbesd_Mn1_f2 PAD$1 VSS VSS VSS nfet L=0.13U W=2U
Mbesd_Mn1_f3 PAD$1 VSS VSS VSS nfet L=0.13U W=2U
Mbesd_Mn1_f4 PAD$1 VSS VSS VSS nfet L=0.13U W=2U
Mbesd_Mn1_f5 PAD$1 VSS VSS VSS nfet L=0.13U W=2U
Mbesd_Mn1_f6 PAD$1 VSS VSS VSS nfet L=0.13U W=2U
Mbesd_Mn1_f7 PAD$1 VSS VSS VSS nfet L=0.13U W=2U
Mbesd_Mn1_f8 PAD$1 VSS VSS VSS nfet L=0.13U W=2U
Mbesd_Mn1_f9 PAD$1 VSS VSS VSS nfet L=0.13U W=2U
Mbesd_Mclamp_f0 VDDIO VSS VSS VSS nfet L=0.35U W=2U
Mbesd_Mclamp_f1 VDDIO VSS VSS VSS nfet L=0.35U W=2U
Mbesd_Mclamp_f2 VDDIO VSS VSS VSS nfet L=0.35U W=2U
Mbesd_Mclamp_f3 VDDIO VSS VSS VSS nfet L=0.35U W=2U
Mbesd_Mclamp_f4 VDDIO VSS VSS VSS nfet L=0.35U W=2U
Mbesd_Mclamp_f5 VDDIO VSS VSS VSS nfet L=0.35U W=2U
Mbesd_Mclamp_f6 VDDIO VSS VSS VSS nfet L=0.35U W=2U
Mbesd_Mclamp_f7 VDDIO VSS VSS VSS nfet L=0.35U W=2U
Mbesd_Mclamp_f8 VDDIO VSS VSS VSS nfet L=0.35U W=2U
Mbesd_Mclamp_f9 VDDIO VSS VSS VSS nfet L=0.35U W=2U
Mbesd_Mclamp_f10 VDDIO VSS VSS VSS nfet L=0.35U W=2U
Mbesd_Mclamp_f11 VDDIO VSS VSS VSS nfet L=0.35U W=2U
Mbesd_Mclamp_f12 VDDIO VSS VSS VSS nfet L=0.35U W=2U
Mbesd_Mclamp_f13 VDDIO VSS VSS VSS nfet L=0.35U W=2U
Mbesd_Mclamp_f14 VDDIO VSS VSS VSS nfet L=0.35U W=2U
Mbesd_Mclamp_f15 VDDIO VSS VSS VSS nfet L=0.35U W=2U
Mbesd_Mclamp_f16 VDDIO VSS VSS VSS nfet L=0.35U W=2U
Mbesd_Mclamp_f17 VDDIO VSS VSS VSS nfet L=0.35U W=2U
Mbesd_Mclamp_f18 VDDIO VSS VSS VSS nfet L=0.35U W=2U
Mbesd_Mclamp_f19 VDDIO VSS VSS VSS nfet L=0.35U W=2U
Xbesd_Resd PAD$1 PADI_B VSS rppd r=294.2 L=2U W=2U
Dbesd_Dp2 PADI_B VDDIO dpantenna A=4P P=8U
Mbesd_Mn2_f0 PADI_B VSS VSS VSS nfet L=0.13U W=1U
Mbtx_Mi1p_f0 btx/OEB OE VDDIO VDDIO pfet L=0.13U W=2U
Mbtx_Mi1n_f0 btx/OEB OE VSS VSS nfet L=0.13U W=1U
Mbtx_Mnd1p_f0 btx/GP DIN VDDIO VDDIO pfet L=0.13U W=2U
Mbtx_Mnd1p_f1 btx/GP DIN VDDIO VDDIO pfet L=0.13U W=2U
Mbtx_Mnd2p_f0 btx/GP OE VDDIO VDDIO pfet L=0.13U W=2U
Mbtx_Mnd2p_f1 btx/GP OE VDDIO VDDIO pfet L=0.13U W=2U
Mbtx_Mnd1n_f0 btx/GP DIN btx/NA VSS nfet L=0.13U W=2U
Mbtx_Mnd1n_f1 btx/GP DIN btx/NA VSS nfet L=0.13U W=2U
Mbtx_Mnd2n_f0 btx/NA OE VSS VSS nfet L=0.13U W=2U
Mbtx_Mnd2n_f1 btx/NA OE VSS VSS nfet L=0.13U W=2U
Mbtx_Mnr1p_f0 btx/NB DIN VDDIO VDDIO pfet L=0.13U W=2U
Mbtx_Mnr1p_f1 btx/NB DIN VDDIO VDDIO pfet L=0.13U W=2U
Mbtx_Mnr2p_f0 btx/GN btx/OEB btx/NB VDDIO pfet L=0.13U W=2U
Mbtx_Mnr2p_f1 btx/GN btx/OEB btx/NB VDDIO pfet L=0.13U W=2U
Mbtx_Mnr1n_f0 btx/GN DIN VSS VSS nfet L=0.13U W=1U
Mbtx_Mnr1n_f1 btx/GN DIN VSS VSS nfet L=0.13U W=1U
Mbtx_Mnr2n_f0 btx/GN btx/OEB VSS VSS nfet L=0.13U W=1U
Mbtx_Mnr2n_f1 btx/GN btx/OEB VSS VSS nfet L=0.13U W=1U
Mbtx_Mp_f0 btx/DP btx/GP VDDIO VDDIO pfet L=0.13U W=1U
Mbtx_Mp_f1 btx/DP btx/GP VDDIO VDDIO pfet L=0.13U W=1U
Mbtx_Mp_f2 btx/DP btx/GP VDDIO VDDIO pfet L=0.13U W=1U
Mbtx_Mp_f3 btx/DP btx/GP VDDIO VDDIO pfet L=0.13U W=1U
Mbtx_Mp_f4 btx/DP btx/GP VDDIO VDDIO pfet L=0.13U W=1U
Mbtx_Mp_f5 btx/DP btx/GP VDDIO VDDIO pfet L=0.13U W=1U
Mbtx_Mp_f6 btx/DP btx/GP VDDIO VDDIO pfet L=0.13U W=1U
Mbtx_Mp_f7 btx/DP btx/GP VDDIO VDDIO pfet L=0.13U W=1U
Mbtx_Mp_f8 btx/DP btx/GP VDDIO VDDIO pfet L=0.13U W=1U
Mbtx_Mp_f9 btx/DP btx/GP VDDIO VDDIO pfet L=0.13U W=1U
Mbtx_Mp_f10 btx/DP btx/GP VDDIO VDDIO pfet L=0.13U W=1U
Mbtx_Mp_f11 btx/DP btx/GP VDDIO VDDIO pfet L=0.13U W=1U
Mbtx_Mp_f12 btx/DP btx/GP VDDIO VDDIO pfet L=0.13U W=1U
Mbtx_Mp_f13 btx/DP btx/GP VDDIO VDDIO pfet L=0.13U W=1U
Mbtx_Mp_f14 btx/DP btx/GP VDDIO VDDIO pfet L=0.13U W=1U
Mbtx_Mp_f15 btx/DP btx/GP VDDIO VDDIO pfet L=0.13U W=1U
Mbtx_Mp_f16 btx/DP btx/GP VDDIO VDDIO pfet L=0.13U W=1U
Mbtx_Mp_f17 btx/DP btx/GP VDDIO VDDIO pfet L=0.13U W=1U
Mbtx_Mp_f18 btx/DP btx/GP VDDIO VDDIO pfet L=0.13U W=1U
Mbtx_Mp_f19 btx/DP btx/GP VDDIO VDDIO pfet L=0.13U W=1U
Mbtx_Mp_f20 btx/DP btx/GP VDDIO VDDIO pfet L=0.13U W=1U
Mbtx_Mp_f21 btx/DP btx/GP VDDIO VDDIO pfet L=0.13U W=1U
Mbtx_Mp_f22 btx/DP btx/GP VDDIO VDDIO pfet L=0.13U W=1U
Mbtx_Mp_f23 btx/DP btx/GP VDDIO VDDIO pfet L=0.13U W=1U
Mbtx_Mp_f24 btx/DP btx/GP VDDIO VDDIO pfet L=0.13U W=1U
Mbtx_Mp_f25 btx/DP btx/GP VDDIO VDDIO pfet L=0.13U W=1U
Mbtx_Mp_f26 btx/DP btx/GP VDDIO VDDIO pfet L=0.13U W=1U
Mbtx_Mp_f27 btx/DP btx/GP VDDIO VDDIO pfet L=0.13U W=1U
Mbtx_Mp_f28 btx/DP btx/GP VDDIO VDDIO pfet L=0.13U W=1U
Mbtx_Mp_f29 btx/DP btx/GP VDDIO VDDIO pfet L=0.13U W=1U
Mbtx_Mp_f30 btx/DP btx/GP VDDIO VDDIO pfet L=0.13U W=1U
Mbtx_Mp_f31 btx/DP btx/GP VDDIO VDDIO pfet L=0.13U W=1U
Mbtx_Mp_f32 btx/DP btx/GP VDDIO VDDIO pfet L=0.13U W=1U
Mbtx_Mp_f33 btx/DP btx/GP VDDIO VDDIO pfet L=0.13U W=1U
Mbtx_Mp_f34 btx/DP btx/GP VDDIO VDDIO pfet L=0.13U W=1U
Mbtx_Mp_f35 btx/DP btx/GP VDDIO VDDIO pfet L=0.13U W=1U
Mbtx_Mp_f36 btx/DP btx/GP VDDIO VDDIO pfet L=0.13U W=1U
Mbtx_Mp_f37 btx/DP btx/GP VDDIO VDDIO pfet L=0.13U W=1U
Mbtx_Mp_f38 btx/DP btx/GP VDDIO VDDIO pfet L=0.13U W=1U
Mbtx_Mp_f39 btx/DP btx/GP VDDIO VDDIO pfet L=0.13U W=1U
Mbtx_Mp_f40 btx/DP btx/GP VDDIO VDDIO pfet L=0.13U W=1U
Mbtx_Mp_f41 btx/DP btx/GP VDDIO VDDIO pfet L=0.13U W=1U
Mbtx_Mp_f42 btx/DP btx/GP VDDIO VDDIO pfet L=0.13U W=1U
Mbtx_Mp_f43 btx/DP btx/GP VDDIO VDDIO pfet L=0.13U W=1U
Mbtx_Mp_f44 btx/DP btx/GP VDDIO VDDIO pfet L=0.13U W=1U
Mbtx_Mp_f45 btx/DP btx/GP VDDIO VDDIO pfet L=0.13U W=1U
Mbtx_Mp_f46 btx/DP btx/GP VDDIO VDDIO pfet L=0.13U W=1U
Mbtx_Mp_f47 btx/DP btx/GP VDDIO VDDIO pfet L=0.13U W=1U
Mbtx_Mp_f48 btx/DP btx/GP VDDIO VDDIO pfet L=0.13U W=1U
Mbtx_Mp_f49 btx/DP btx/GP VDDIO VDDIO pfet L=0.13U W=1U
Mbtx_Mp_f50 btx/DP btx/GP VDDIO VDDIO pfet L=0.13U W=1U
Mbtx_Mp_f51 btx/DP btx/GP VDDIO VDDIO pfet L=0.13U W=1U
Mbtx_Mp_f52 btx/DP btx/GP VDDIO VDDIO pfet L=0.13U W=1U
Mbtx_Mp_f53 btx/DP btx/GP VDDIO VDDIO pfet L=0.13U W=1U
Mbtx_Mn_f0 btx/DN btx/GN VSS VSS nfet L=0.13U W=1U
Mbtx_Mn_f1 btx/DN btx/GN VSS VSS nfet L=0.13U W=1U
Mbtx_Mn_f2 btx/DN btx/GN VSS VSS nfet L=0.13U W=1U
Mbtx_Mn_f3 btx/DN btx/GN VSS VSS nfet L=0.13U W=1U
Mbtx_Mn_f4 btx/DN btx/GN VSS VSS nfet L=0.13U W=1U
Mbtx_Mn_f5 btx/DN btx/GN VSS VSS nfet L=0.13U W=1U
Mbtx_Mn_f6 btx/DN btx/GN VSS VSS nfet L=0.13U W=1U
Mbtx_Mn_f7 btx/DN btx/GN VSS VSS nfet L=0.13U W=1U
Mbtx_Mn_f8 btx/DN btx/GN VSS VSS nfet L=0.13U W=1U
Mbtx_Mn_f9 btx/DN btx/GN VSS VSS nfet L=0.13U W=1U
Mbtx_Mn_f10 btx/DN btx/GN VSS VSS nfet L=0.13U W=1U
Mbtx_Mn_f11 btx/DN btx/GN VSS VSS nfet L=0.13U W=1U
Mbtx_Mn_f12 btx/DN btx/GN VSS VSS nfet L=0.13U W=1U
Mbtx_Mn_f13 btx/DN btx/GN VSS VSS nfet L=0.13U W=1U
Mbtx_Mn_f14 btx/DN btx/GN VSS VSS nfet L=0.13U W=1U
Mbtx_Mn_f15 btx/DN btx/GN VSS VSS nfet L=0.13U W=1U
Mbtx_Mn_f16 btx/DN btx/GN VSS VSS nfet L=0.13U W=1U
Mbtx_Mn_f17 btx/DN btx/GN VSS VSS nfet L=0.13U W=1U
Mbtx_Mn_f18 btx/DN btx/GN VSS VSS nfet L=0.13U W=1U
Mbtx_Mn_f19 btx/DN btx/GN VSS VSS nfet L=0.13U W=1U
Mbtx_Mn_f20 btx/DN btx/GN VSS VSS nfet L=0.13U W=1U
Mbtx_Mn_f21 btx/DN btx/GN VSS VSS nfet L=0.13U W=1U
Mbtx_Mpu_f0 btx/PUX PUN VDDIO VDDIO pfet L=0.13U W=2U
Xbtx_Rpu btx/PUX PAD$1 VSS rppd r=12472.0 L=24U W=0.5U
Mbtx_Mpd_f0 btx/PDX PD VSS VSS nfet L=0.13U W=1U
Xbtx_Rpd PAD$1 btx/PDX VSS rppd r=12472.0 L=24U W=0.5U
Xbtx_Rsp btx/DP PAD$1 VSS rppd r=20.0 L=0.5U W=10U
Xbtx_Rsn btx/DN PAD$1 VSS rppd r=20.0 L=0.5U W=10U
.ENDS
