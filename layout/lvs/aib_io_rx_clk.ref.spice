* Generated by layout/lvs/gen_reference.py -- DO NOT EDIT BY HAND.
* Plain-element form for `klt lvs`; flattened from the item 1 netlists:
*   design/aib_pad_esd.spice sha256:3cb704eb07544c97702c141626fe54285850dfc17a7ca20932c3bc24c6609489
*   design/aib_tx_data.spice sha256:667c53139825da4804873cab2f2038c4576063c466dfb9ce16c1a9a527bbf545
*   design/aib_rx_data.spice sha256:7863828c03ab4412c465be9931b6f8172fc90fe572ec64c72c4bb36cc34d6774
*   design/aib_rx_inv.spice sha256:8cd42264f8014ff28951be5fb52e9ed94fadb94b89fc99aba5291e6d6b8b90fe
*   design/aib_tx_clk.spice sha256:35de4d0bc6f1ad109c1477efa0cde485ae7a39f1b90005e92a2a0fd7db55e248
*   design/aib_rx_clk.spice sha256:3675d8bb85f776fda07a1183adfd3b846062bd034c49d054a4f905cf58a95bb7
.SUBCKT aib_io_rx_clk DOUT DOUT$1 PAD PAD$1 VDDIO VSS
Daesd_Dp1 PAD VDDIO diodevdd_mod A=35P P=58.08U
Daesd_Dp1_dsub VSS VDDIO dsub_2kv_mod A=224.956P P=81.12U
Maesd_Mn1_f0 PAD VSS VSS VSS nfet L=0.13U W=2U
Maesd_Mn1_f1 PAD VSS VSS VSS nfet L=0.13U W=2U
Maesd_Mn1_f2 PAD VSS VSS VSS nfet L=0.13U W=2U
Maesd_Mn1_f3 PAD VSS VSS VSS nfet L=0.13U W=2U
Maesd_Mn1_f4 PAD VSS VSS VSS nfet L=0.13U W=2U
Maesd_Mn1_f5 PAD VSS VSS VSS nfet L=0.13U W=2U
Maesd_Mn1_f6 PAD VSS VSS VSS nfet L=0.13U W=2U
Maesd_Mn1_f7 PAD VSS VSS VSS nfet L=0.13U W=2U
Maesd_Mn1_f8 PAD VSS VSS VSS nfet L=0.13U W=2U
Maesd_Mn1_f9 PAD VSS VSS VSS nfet L=0.13U W=2U
Maesd_Mclamp_f0 VDDIO VSS VSS VSS nfet L=0.35U W=2U
Maesd_Mclamp_f1 VDDIO VSS VSS VSS nfet L=0.35U W=2U
Maesd_Mclamp_f2 VDDIO VSS VSS VSS nfet L=0.35U W=2U
Maesd_Mclamp_f3 VDDIO VSS VSS VSS nfet L=0.35U W=2U
Maesd_Mclamp_f4 VDDIO VSS VSS VSS nfet L=0.35U W=2U
Maesd_Mclamp_f5 VDDIO VSS VSS VSS nfet L=0.35U W=2U
Maesd_Mclamp_f6 VDDIO VSS VSS VSS nfet L=0.35U W=2U
Maesd_Mclamp_f7 VDDIO VSS VSS VSS nfet L=0.35U W=2U
Maesd_Mclamp_f8 VDDIO VSS VSS VSS nfet L=0.35U W=2U
Maesd_Mclamp_f9 VDDIO VSS VSS VSS nfet L=0.35U W=2U
Maesd_Mclamp_f10 VDDIO VSS VSS VSS nfet L=0.35U W=2U
Maesd_Mclamp_f11 VDDIO VSS VSS VSS nfet L=0.35U W=2U
Maesd_Mclamp_f12 VDDIO VSS VSS VSS nfet L=0.35U W=2U
Maesd_Mclamp_f13 VDDIO VSS VSS VSS nfet L=0.35U W=2U
Maesd_Mclamp_f14 VDDIO VSS VSS VSS nfet L=0.35U W=2U
Maesd_Mclamp_f15 VDDIO VSS VSS VSS nfet L=0.35U W=2U
Maesd_Mclamp_f16 VDDIO VSS VSS VSS nfet L=0.35U W=2U
Maesd_Mclamp_f17 VDDIO VSS VSS VSS nfet L=0.35U W=2U
Maesd_Mclamp_f18 VDDIO VSS VSS VSS nfet L=0.35U W=2U
Maesd_Mclamp_f19 VDDIO VSS VSS VSS nfet L=0.35U W=2U
Xaesd_Resd PAD PADI_A VSS rppd r=164.6 L=1U W=2U
Daesd_Dp2 PADI_A VDDIO dpantenna A=4P P=8U
Maesd_Mn2_f0 PADI_A VSS VSS VSS nfet L=0.13U W=1U
Mainv_Mi1p_f0 ainv/M1 PADI_A VDDIO VDDIO pfet L=0.13U W=1.25U
Mainv_Mi1p_f1 ainv/M1 PADI_A VDDIO VDDIO pfet L=0.13U W=1.25U
Mainv_Mi1n_f0 ainv/M1 PADI_A VSS VSS nfet L=0.13U W=0.5U
Mainv_Mi1n_f1 ainv/M1 PADI_A VSS VSS nfet L=0.13U W=0.5U
Mainv_Mi2p_f0 DOUT$1 ainv/M1 VDDIO VDDIO pfet L=0.13U W=2U
Mainv_Mi2p_f1 DOUT$1 ainv/M1 VDDIO VDDIO pfet L=0.13U W=2U
Mainv_Mi2n_f0 DOUT$1 ainv/M1 VSS VSS nfet L=0.13U W=1U
Mainv_Mi2n_f1 DOUT$1 ainv/M1 VSS VSS nfet L=0.13U W=1U
Dbesd_Dp1 PAD$1 VDDIO diodevdd_mod A=35P P=58.08U
Dbesd_Dp1_dsub VSS VDDIO dsub_2kv_mod A=224.956P P=81.12U
Mbesd_Mn1_f0 PAD$1 VSS VSS VSS nfet L=0.13U W=2U
Mbesd_Mn1_f1 PAD$1 VSS VSS VSS nfet L=0.13U W=2U
Mbesd_Mn1_f2 PAD$1 VSS VSS VSS nfet L=0.13U W=2U
Mbesd_Mn1_f3 PAD$1 VSS VSS VSS nfet L=0.13U W=2U
Mbesd_Mn1_f4 PAD$1 VSS VSS VSS nfet L=0.13U W=2U
Mbesd_Mn1_f5 PAD$1 VSS VSS VSS nfet L=0.13U W=2U
Mbesd_Mn1_f6 PAD$1 VSS VSS VSS nfet L=0.13U W=2U
Mbesd_Mn1_f7 PAD$1 VSS VSS VSS nfet L=0.13U W=2U
Mbesd_Mn1_f8 PAD$1 VSS VSS VSS nfet L=0.13U W=2U
Mbesd_Mn1_f9 PAD$1 VSS VSS VSS nfet L=0.13U W=2U
Mbesd_Mclamp_f0 VDDIO VSS VSS VSS nfet L=0.35U W=2U
Mbesd_Mclamp_f1 VDDIO VSS VSS VSS nfet L=0.35U W=2U
Mbesd_Mclamp_f2 VDDIO VSS VSS VSS nfet L=0.35U W=2U
Mbesd_Mclamp_f3 VDDIO VSS VSS VSS nfet L=0.35U W=2U
Mbesd_Mclamp_f4 VDDIO VSS VSS VSS nfet L=0.35U W=2U
Mbesd_Mclamp_f5 VDDIO VSS VSS VSS nfet L=0.35U W=2U
Mbesd_Mclamp_f6 VDDIO VSS VSS VSS nfet L=0.35U W=2U
Mbesd_Mclamp_f7 VDDIO VSS VSS VSS nfet L=0.35U W=2U
Mbesd_Mclamp_f8 VDDIO VSS VSS VSS nfet L=0.35U W=2U
Mbesd_Mclamp_f9 VDDIO VSS VSS VSS nfet L=0.35U W=2U
Mbesd_Mclamp_f10 VDDIO VSS VSS VSS nfet L=0.35U W=2U
Mbesd_Mclamp_f11 VDDIO VSS VSS VSS nfet L=0.35U W=2U
Mbesd_Mclamp_f12 VDDIO VSS VSS VSS nfet L=0.35U W=2U
Mbesd_Mclamp_f13 VDDIO VSS VSS VSS nfet L=0.35U W=2U
Mbesd_Mclamp_f14 VDDIO VSS VSS VSS nfet L=0.35U W=2U
Mbesd_Mclamp_f15 VDDIO VSS VSS VSS nfet L=0.35U W=2U
Mbesd_Mclamp_f16 VDDIO VSS VSS VSS nfet L=0.35U W=2U
Mbesd_Mclamp_f17 VDDIO VSS VSS VSS nfet L=0.35U W=2U
Mbesd_Mclamp_f18 VDDIO VSS VSS VSS nfet L=0.35U W=2U
Mbesd_Mclamp_f19 VDDIO VSS VSS VSS nfet L=0.35U W=2U
Xbesd_Resd PAD$1 PADI_B VSS rppd r=164.6 L=1U W=2U
Dbesd_Dp2 PADI_B VDDIO dpantenna A=4P P=8U
Mbesd_Mn2_f0 PADI_B VSS VSS VSS nfet L=0.13U W=1U
Mbinv_Mi1p_f0 binv/M1 PADI_B VDDIO VDDIO pfet L=0.13U W=1.25U
Mbinv_Mi1p_f1 binv/M1 PADI_B VDDIO VDDIO pfet L=0.13U W=1.25U
Mbinv_Mi1n_f0 binv/M1 PADI_B VSS VSS nfet L=0.13U W=0.5U
Mbinv_Mi1n_f1 binv/M1 PADI_B VSS VSS nfet L=0.13U W=0.5U
Mbinv_Mi2p_f0 DOUT binv/M1 VDDIO VDDIO pfet L=0.13U W=2U
Mbinv_Mi2p_f1 DOUT binv/M1 VDDIO VDDIO pfet L=0.13U W=2U
Mbinv_Mi2n_f0 DOUT binv/M1 VSS VSS nfet L=0.13U W=1U
Mbinv_Mi2n_f1 DOUT binv/M1 VSS VSS nfet L=0.13U W=1U
.ENDS
