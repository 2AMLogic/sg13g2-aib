* Generated by layout/lvs/gen_reference.py -- DO NOT EDIT BY HAND.
* Plain-element form for `klt lvs`; flattened from the item 1 netlists:
*   design/aib_pad_esd.spice sha256:86d410385d099254f0376b9b4638cd18dfee8e7ae538a45e2ed85e2cdea415d5
*   design/aib_tx_data.spice sha256:adf7d751f8645148fe68be97b8d1ade38a2eadbf5432e05eed059c570850d2d7
*   design/aib_rx_data.spice sha256:43f326de980bc5a817d6235ab5402de4aa02886619ead25e7e60c41dfef99eab
*   design/aib_tx_clk.spice sha256:d2bdf119e914678106c566674093ccc54b75174d76592851cfd98db57dce32ad
*   design/aib_rx_clk.spice sha256:0e53de36f4d0d2585452746bb2cb5d35e7c8b0801cdf597efe1dbb7bc01b5b2d
.SUBCKT aib_io_rx_clk DOUT DOUT$1 PAD PAD$1 VDDIO VSS
Daesd_Dp1 PAD VDDIO dpantenna A=100P P=40U
Daesd_Dn1 VSS PAD dantenna A=100P P=40U
Maesd_Mclamp_f0 VDDIO VSS VSS VSS nfet L=0.35U W=2U
Maesd_Mclamp_f1 VDDIO VSS VSS VSS nfet L=0.35U W=2U
Maesd_Mclamp_f2 VDDIO VSS VSS VSS nfet L=0.35U W=2U
Maesd_Mclamp_f3 VDDIO VSS VSS VSS nfet L=0.35U W=2U
Maesd_Mclamp_f4 VDDIO VSS VSS VSS nfet L=0.35U W=2U
Maesd_Mclamp_f5 VDDIO VSS VSS VSS nfet L=0.35U W=2U
Maesd_Mclamp_f6 VDDIO VSS VSS VSS nfet L=0.35U W=2U
Maesd_Mclamp_f7 VDDIO VSS VSS VSS nfet L=0.35U W=2U
Maesd_Mclamp_f8 VDDIO VSS VSS VSS nfet L=0.35U W=2U
Maesd_Mclamp_f9 VDDIO VSS VSS VSS nfet L=0.35U W=2U
Maesd_Mclamp_f10 VDDIO VSS VSS VSS nfet L=0.35U W=2U
Maesd_Mclamp_f11 VDDIO VSS VSS VSS nfet L=0.35U W=2U
Maesd_Mclamp_f12 VDDIO VSS VSS VSS nfet L=0.35U W=2U
Maesd_Mclamp_f13 VDDIO VSS VSS VSS nfet L=0.35U W=2U
Maesd_Mclamp_f14 VDDIO VSS VSS VSS nfet L=0.35U W=2U
Maesd_Mclamp_f15 VDDIO VSS VSS VSS nfet L=0.35U W=2U
Maesd_Mclamp_f16 VDDIO VSS VSS VSS nfet L=0.35U W=2U
Maesd_Mclamp_f17 VDDIO VSS VSS VSS nfet L=0.35U W=2U
Maesd_Mclamp_f18 VDDIO VSS VSS VSS nfet L=0.35U W=2U
Maesd_Mclamp_f19 VDDIO VSS VSS VSS nfet L=0.35U W=2U
Xaesd_Resd PAD PADI_A VSS rppd r=294.2 L=2U W=2U
Daesd_Dp2 PADI_A VDDIO dpantenna A=4P P=8U
Maesd_Mn2_f0 PADI_A VSS VSS VSS nfet L=0.13U W=1U
Marx_Mi1p_f0 arx/M1 PADI_A VDDIO VDDIO pfet L=0.13U W=1.25U
Marx_Mi1p_f1 arx/M1 PADI_A VDDIO VDDIO pfet L=0.13U W=1.25U
Marx_Mi1n_f0 arx/M1 PADI_A VSS VSS nfet L=0.13U W=0.5U
Marx_Mi1n_f1 arx/M1 PADI_A VSS VSS nfet L=0.13U W=0.5U
Marx_Mi2p_f0 DOUT arx/M1 VDDIO VDDIO pfet L=0.13U W=2U
Marx_Mi2p_f1 DOUT arx/M1 VDDIO VDDIO pfet L=0.13U W=2U
Marx_Mi2n_f0 DOUT arx/M1 VSS VSS nfet L=0.13U W=1U
Marx_Mi2n_f1 DOUT arx/M1 VSS VSS nfet L=0.13U W=1U
Dbesd_Dp1 PAD$1 VDDIO dpantenna A=100P P=40U
Dbesd_Dn1 VSS PAD$1 dantenna A=100P P=40U
Mbesd_Mclamp_f0 VDDIO VSS VSS VSS nfet L=0.35U W=2U
Mbesd_Mclamp_f1 VDDIO VSS VSS VSS nfet L=0.35U W=2U
Mbesd_Mclamp_f2 VDDIO VSS VSS VSS nfet L=0.35U W=2U
Mbesd_Mclamp_f3 VDDIO VSS VSS VSS nfet L=0.35U W=2U
Mbesd_Mclamp_f4 VDDIO VSS VSS VSS nfet L=0.35U W=2U
Mbesd_Mclamp_f5 VDDIO VSS VSS VSS nfet L=0.35U W=2U
Mbesd_Mclamp_f6 VDDIO VSS VSS VSS nfet L=0.35U W=2U
Mbesd_Mclamp_f7 VDDIO VSS VSS VSS nfet L=0.35U W=2U
Mbesd_Mclamp_f8 VDDIO VSS VSS VSS nfet L=0.35U W=2U
Mbesd_Mclamp_f9 VDDIO VSS VSS VSS nfet L=0.35U W=2U
Mbesd_Mclamp_f10 VDDIO VSS VSS VSS nfet L=0.35U W=2U
Mbesd_Mclamp_f11 VDDIO VSS VSS VSS nfet L=0.35U W=2U
Mbesd_Mclamp_f12 VDDIO VSS VSS VSS nfet L=0.35U W=2U
Mbesd_Mclamp_f13 VDDIO VSS VSS VSS nfet L=0.35U W=2U
Mbesd_Mclamp_f14 VDDIO VSS VSS VSS nfet L=0.35U W=2U
Mbesd_Mclamp_f15 VDDIO VSS VSS VSS nfet L=0.35U W=2U
Mbesd_Mclamp_f16 VDDIO VSS VSS VSS nfet L=0.35U W=2U
Mbesd_Mclamp_f17 VDDIO VSS VSS VSS nfet L=0.35U W=2U
Mbesd_Mclamp_f18 VDDIO VSS VSS VSS nfet L=0.35U W=2U
Mbesd_Mclamp_f19 VDDIO VSS VSS VSS nfet L=0.35U W=2U
Xbesd_Resd PAD$1 PADI_B VSS rppd r=294.2 L=2U W=2U
Dbesd_Dp2 PADI_B VDDIO dpantenna A=4P P=8U
Mbesd_Mn2_f0 PADI_B VSS VSS VSS nfet L=0.13U W=1U
Mbrx_Mi1p_f0 brx/M1 PADI_B VDDIO VDDIO pfet L=0.13U W=1.25U
Mbrx_Mi1p_f1 brx/M1 PADI_B VDDIO VDDIO pfet L=0.13U W=1.25U
Mbrx_Mi1n_f0 brx/M1 PADI_B VSS VSS nfet L=0.13U W=0.5U
Mbrx_Mi1n_f1 brx/M1 PADI_B VSS VSS nfet L=0.13U W=0.5U
Mbrx_Mi2p_f0 DOUT$1 brx/M1 VDDIO VDDIO pfet L=0.13U W=2U
Mbrx_Mi2p_f1 DOUT$1 brx/M1 VDDIO VDDIO pfet L=0.13U W=2U
Mbrx_Mi2n_f0 DOUT$1 brx/M1 VSS VSS nfet L=0.13U W=1U
Mbrx_Mi2n_f1 DOUT$1 brx/M1 VSS VSS nfet L=0.13U W=1U
.ENDS
