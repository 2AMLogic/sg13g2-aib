* DIAGNOSTIC reference (see layout/lvs/README.md); not a result reference.
* Generated by layout/lvs/gen_reference.py -- DO NOT EDIT BY HAND.
* Plain-element form for `klt lvs`; flattened from the item 1 netlists:
*   design/aib_pad_esd.spice sha256:86d410385d099254f0376b9b4638cd18dfee8e7ae538a45e2ed85e2cdea415d5
*   design/aib_tx_data.spice sha256:adf7d751f8645148fe68be97b8d1ade38a2eadbf5432e05eed059c570850d2d7
*   design/aib_rx_data.spice sha256:43f326de980bc5a817d6235ab5402de4aa02886619ead25e7e60c41dfef99eab
*   design/aib_tx_clk.spice sha256:d2bdf119e914678106c566674093ccc54b75174d76592851cfd98db57dce32ad
*   design/aib_rx_clk.spice sha256:0e53de36f4d0d2585452746bb2cb5d35e7c8b0801cdf597efe1dbb7bc01b5b2d
.SUBCKT aib_io_tx DIN OE PAD PD PUN VDDIO VSS
Desd_Dp1 PAD VDDIO dpantenna A=100P P=40U
Desd_Dn1 VSS PAD dantenna A=100P P=40U
Mesd_Mclamp_f0 VDDIO VSS VSS VSS nfet L=0.35U W=2U
Mesd_Mclamp_f1 VDDIO VSS VSS VSS nfet L=0.35U W=2U
Mesd_Mclamp_f2 VDDIO VSS VSS VSS nfet L=0.35U W=2U
Mesd_Mclamp_f3 VDDIO VSS VSS VSS nfet L=0.35U W=2U
Mesd_Mclamp_f4 VDDIO VSS VSS VSS nfet L=0.35U W=2U
Mesd_Mclamp_f5 VDDIO VSS VSS VSS nfet L=0.35U W=2U
Mesd_Mclamp_f6 VDDIO VSS VSS VSS nfet L=0.35U W=2U
Mesd_Mclamp_f7 VDDIO VSS VSS VSS nfet L=0.35U W=2U
Mesd_Mclamp_f8 VDDIO VSS VSS VSS nfet L=0.35U W=2U
Mesd_Mclamp_f9 VDDIO VSS VSS VSS nfet L=0.35U W=2U
Mesd_Mclamp_f10 VDDIO VSS VSS VSS nfet L=0.35U W=2U
Mesd_Mclamp_f11 VDDIO VSS VSS VSS nfet L=0.35U W=2U
Mesd_Mclamp_f12 VDDIO VSS VSS VSS nfet L=0.35U W=2U
Mesd_Mclamp_f13 VDDIO VSS VSS VSS nfet L=0.35U W=2U
Mesd_Mclamp_f14 VDDIO VSS VSS VSS nfet L=0.35U W=2U
Mesd_Mclamp_f15 VDDIO VSS VSS VSS nfet L=0.35U W=2U
Mesd_Mclamp_f16 VDDIO VSS VSS VSS nfet L=0.35U W=2U
Mesd_Mclamp_f17 VDDIO VSS VSS VSS nfet L=0.35U W=2U
Mesd_Mclamp_f18 VDDIO VSS VSS VSS nfet L=0.35U W=2U
Mesd_Mclamp_f19 VDDIO VSS VSS VSS nfet L=0.35U W=2U
Xesd_Resd PAD VSS VSS rppd r=294.2 L=2U W=2U
Desd_Dp2 VSS VDDIO dpantenna A=4P P=8U
Mesd_Mn2_f0 VSS VSS VSS VSS nfet L=0.13U W=1U
Mtx_Mi1p_f0 tx/OEB OE VDDIO VDDIO pfet L=0.13U W=2U
Mtx_Mi1n_f0 tx/OEB OE VSS VSS nfet L=0.13U W=1U
Mtx_Mnd1p_f0 tx/GP DIN VDDIO VDDIO pfet L=0.13U W=4U
Mtx_Mnd1p_f1 tx/GP DIN VDDIO VDDIO pfet L=0.13U W=4U
Mtx_Mnd2p_f0 tx/GP OE VDDIO VDDIO pfet L=0.13U W=4U
Mtx_Mnd2p_f1 tx/GP OE VDDIO VDDIO pfet L=0.13U W=4U
Mtx_Mnd1n_f0 tx/GP DIN tx/NA VSS nfet L=0.13U W=4U
Mtx_Mnd1n_f1 tx/GP DIN tx/NA VSS nfet L=0.13U W=4U
Mtx_Mnd2n_f0 tx/NA OE VSS VSS nfet L=0.13U W=4U
Mtx_Mnd2n_f1 tx/NA OE VSS VSS nfet L=0.13U W=4U
Mtx_Mnr1p_f0 tx/NB DIN VDDIO VDDIO pfet L=0.13U W=4U
Mtx_Mnr1p_f1 tx/NB DIN VDDIO VDDIO pfet L=0.13U W=4U
Mtx_Mnr2p_f0 tx/GN tx/OEB tx/NB VDDIO pfet L=0.13U W=4U
Mtx_Mnr2p_f1 tx/GN tx/OEB tx/NB VDDIO pfet L=0.13U W=4U
Mtx_Mnr1n_f0 tx/GN DIN VSS VSS nfet L=0.13U W=2U
Mtx_Mnr1n_f1 tx/GN DIN VSS VSS nfet L=0.13U W=2U
Mtx_Mnr2n_f0 tx/GN tx/OEB VSS VSS nfet L=0.13U W=2U
Mtx_Mnr2n_f1 tx/GN tx/OEB VSS VSS nfet L=0.13U W=2U
Mtx_Mp_f0 PAD tx/GP VDDIO VDDIO pfet L=0.13U W=1U
Mtx_Mp_f1 PAD tx/GP VDDIO VDDIO pfet L=0.13U W=1U
Mtx_Mp_f2 PAD tx/GP VDDIO VDDIO pfet L=0.13U W=1U
Mtx_Mp_f3 PAD tx/GP VDDIO VDDIO pfet L=0.13U W=1U
Mtx_Mp_f4 PAD tx/GP VDDIO VDDIO pfet L=0.13U W=1U
Mtx_Mp_f5 PAD tx/GP VDDIO VDDIO pfet L=0.13U W=1U
Mtx_Mp_f6 PAD tx/GP VDDIO VDDIO pfet L=0.13U W=1U
Mtx_Mp_f7 PAD tx/GP VDDIO VDDIO pfet L=0.13U W=1U
Mtx_Mp_f8 PAD tx/GP VDDIO VDDIO pfet L=0.13U W=1U
Mtx_Mp_f9 PAD tx/GP VDDIO VDDIO pfet L=0.13U W=1U
Mtx_Mp_f10 PAD tx/GP VDDIO VDDIO pfet L=0.13U W=1U
Mtx_Mp_f11 PAD tx/GP VDDIO VDDIO pfet L=0.13U W=1U
Mtx_Mp_f12 PAD tx/GP VDDIO VDDIO pfet L=0.13U W=1U
Mtx_Mp_f13 PAD tx/GP VDDIO VDDIO pfet L=0.13U W=1U
Mtx_Mp_f14 PAD tx/GP VDDIO VDDIO pfet L=0.13U W=1U
Mtx_Mp_f15 PAD tx/GP VDDIO VDDIO pfet L=0.13U W=1U
Mtx_Mp_f16 PAD tx/GP VDDIO VDDIO pfet L=0.13U W=1U
Mtx_Mp_f17 PAD tx/GP VDDIO VDDIO pfet L=0.13U W=1U
Mtx_Mp_f18 PAD tx/GP VDDIO VDDIO pfet L=0.13U W=1U
Mtx_Mp_f19 PAD tx/GP VDDIO VDDIO pfet L=0.13U W=1U
Mtx_Mp_f20 PAD tx/GP VDDIO VDDIO pfet L=0.13U W=1U
Mtx_Mp_f21 PAD tx/GP VDDIO VDDIO pfet L=0.13U W=1U
Mtx_Mp_f22 PAD tx/GP VDDIO VDDIO pfet L=0.13U W=1U
Mtx_Mp_f23 PAD tx/GP VDDIO VDDIO pfet L=0.13U W=1U
Mtx_Mp_f24 PAD tx/GP VDDIO VDDIO pfet L=0.13U W=1U
Mtx_Mp_f25 PAD tx/GP VDDIO VDDIO pfet L=0.13U W=1U
Mtx_Mp_f26 PAD tx/GP VDDIO VDDIO pfet L=0.13U W=1U
Mtx_Mp_f27 PAD tx/GP VDDIO VDDIO pfet L=0.13U W=1U
Mtx_Mn_f0 PAD tx/GN VSS VSS nfet L=0.13U W=1U
Mtx_Mn_f1 PAD tx/GN VSS VSS nfet L=0.13U W=1U
Mtx_Mn_f2 PAD tx/GN VSS VSS nfet L=0.13U W=1U
Mtx_Mn_f3 PAD tx/GN VSS VSS nfet L=0.13U W=1U
Mtx_Mn_f4 PAD tx/GN VSS VSS nfet L=0.13U W=1U
Mtx_Mn_f5 PAD tx/GN VSS VSS nfet L=0.13U W=1U
Mtx_Mn_f6 PAD tx/GN VSS VSS nfet L=0.13U W=1U
Mtx_Mn_f7 PAD tx/GN VSS VSS nfet L=0.13U W=1U
Mtx_Mn_f8 PAD tx/GN VSS VSS nfet L=0.13U W=1U
Mtx_Mn_f9 PAD tx/GN VSS VSS nfet L=0.13U W=1U
Mtx_Mn_f10 PAD tx/GN VSS VSS nfet L=0.13U W=1U
Mtx_Mn_f11 PAD tx/GN VSS VSS nfet L=0.13U W=1U
Mtx_Mn_f12 PAD tx/GN VSS VSS nfet L=0.13U W=1U
Mtx_Mn_f13 PAD tx/GN VSS VSS nfet L=0.13U W=1U
Mtx_Mpu_f0 tx/PUX PUN VDDIO VDDIO pfet L=0.13U W=2U
Xtx_Rpu tx/PUX PAD VSS rppd r=12472.0 L=24U W=0.5U
Mtx_Mpd_f0 tx/PDX PD VSS VSS nfet L=0.13U W=1U
Xtx_Rpd PAD tx/PDX VSS rppd r=12472.0 L=24U W=0.5U
.ENDS
