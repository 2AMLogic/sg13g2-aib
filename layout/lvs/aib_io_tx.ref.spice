* Generated by layout/lvs/gen_reference.py -- DO NOT EDIT BY HAND.
* Plain-element form for `klt lvs`; flattened from the item 1 netlists:
*   design/aib_pad_esd.spice sha256:3cb704eb07544c97702c141626fe54285850dfc17a7ca20932c3bc24c6609489
*   design/aib_tx_data.spice sha256:667c53139825da4804873cab2f2038c4576063c466dfb9ce16c1a9a527bbf545
*   design/aib_rx_data.spice sha256:7863828c03ab4412c465be9931b6f8172fc90fe572ec64c72c4bb36cc34d6774
*   design/aib_rx_inv.spice sha256:8cd42264f8014ff28951be5fb52e9ed94fadb94b89fc99aba5291e6d6b8b90fe
*   design/aib_tx_clk.spice sha256:35de4d0bc6f1ad109c1477efa0cde485ae7a39f1b90005e92a2a0fd7db55e248
*   design/aib_rx_clk.spice sha256:3675d8bb85f776fda07a1183adfd3b846062bd034c49d054a4f905cf58a95bb7
.SUBCKT aib_io_tx DIN OE PAD PD PUN VDDIO VSS
Desd_Dp1 PAD VDDIO diodevdd_mod A=35P P=58.08U
Desd_Dp1_dsub VSS VDDIO dsub_2kv_mod A=224.956P P=81.12U
Mesd_Mn1_f0 PAD VSS VSS VSS nfet L=0.13U W=2U
Mesd_Mn1_f1 PAD VSS VSS VSS nfet L=0.13U W=2U
Mesd_Mn1_f2 PAD VSS VSS VSS nfet L=0.13U W=2U
Mesd_Mn1_f3 PAD VSS VSS VSS nfet L=0.13U W=2U
Mesd_Mn1_f4 PAD VSS VSS VSS nfet L=0.13U W=2U
Mesd_Mn1_f5 PAD VSS VSS VSS nfet L=0.13U W=2U
Mesd_Mn1_f6 PAD VSS VSS VSS nfet L=0.13U W=2U
Mesd_Mn1_f7 PAD VSS VSS VSS nfet L=0.13U W=2U
Mesd_Mn1_f8 PAD VSS VSS VSS nfet L=0.13U W=2U
Mesd_Mn1_f9 PAD VSS VSS VSS nfet L=0.13U W=2U
Mesd_Mclamp_f0 VDDIO VSS VSS VSS nfet L=0.35U W=2U
Mesd_Mclamp_f1 VDDIO VSS VSS VSS nfet L=0.35U W=2U
Mesd_Mclamp_f2 VDDIO VSS VSS VSS nfet L=0.35U W=2U
Mesd_Mclamp_f3 VDDIO VSS VSS VSS nfet L=0.35U W=2U
Mesd_Mclamp_f4 VDDIO VSS VSS VSS nfet L=0.35U W=2U
Mesd_Mclamp_f5 VDDIO VSS VSS VSS nfet L=0.35U W=2U
Mesd_Mclamp_f6 VDDIO VSS VSS VSS nfet L=0.35U W=2U
Mesd_Mclamp_f7 VDDIO VSS VSS VSS nfet L=0.35U W=2U
Mesd_Mclamp_f8 VDDIO VSS VSS VSS nfet L=0.35U W=2U
Mesd_Mclamp_f9 VDDIO VSS VSS VSS nfet L=0.35U W=2U
Mesd_Mclamp_f10 VDDIO VSS VSS VSS nfet L=0.35U W=2U
Mesd_Mclamp_f11 VDDIO VSS VSS VSS nfet L=0.35U W=2U
Mesd_Mclamp_f12 VDDIO VSS VSS VSS nfet L=0.35U W=2U
Mesd_Mclamp_f13 VDDIO VSS VSS VSS nfet L=0.35U W=2U
Mesd_Mclamp_f14 VDDIO VSS VSS VSS nfet L=0.35U W=2U
Mesd_Mclamp_f15 VDDIO VSS VSS VSS nfet L=0.35U W=2U
Mesd_Mclamp_f16 VDDIO VSS VSS VSS nfet L=0.35U W=2U
Mesd_Mclamp_f17 VDDIO VSS VSS VSS nfet L=0.35U W=2U
Mesd_Mclamp_f18 VDDIO VSS VSS VSS nfet L=0.35U W=2U
Mesd_Mclamp_f19 VDDIO VSS VSS VSS nfet L=0.35U W=2U
Xesd_Resd PAD PADI VSS rppd r=164.6 L=1U W=2U
Desd_Dp2 PADI VDDIO dpantenna A=4P P=8U
Mesd_Mn2_f0 PADI VSS VSS VSS nfet L=0.13U W=1U
Mtx_Mi1p_f0 tx/OEB OE VDDIO VDDIO pfet L=0.13U W=2U
Mtx_Mi1n_f0 tx/OEB OE VSS VSS nfet L=0.13U W=1U
Mtx_Mnd1p_f0 tx/GP DIN VDDIO VDDIO pfet L=0.13U W=2U
Mtx_Mnd1p_f1 tx/GP DIN VDDIO VDDIO pfet L=0.13U W=2U
Mtx_Mnd2p_f0 tx/GP OE VDDIO VDDIO pfet L=0.13U W=2U
Mtx_Mnd2p_f1 tx/GP OE VDDIO VDDIO pfet L=0.13U W=2U
Mtx_Mnd1n_f0 tx/GP DIN tx/NA VSS nfet L=0.13U W=2U
Mtx_Mnd1n_f1 tx/GP DIN tx/NA VSS nfet L=0.13U W=2U
Mtx_Mnd2n_f0 tx/NA OE VSS VSS nfet L=0.13U W=2U
Mtx_Mnd2n_f1 tx/NA OE VSS VSS nfet L=0.13U W=2U
Mtx_Mnr1p_f0 tx/NB DIN VDDIO VDDIO pfet L=0.13U W=2U
Mtx_Mnr1p_f1 tx/NB DIN VDDIO VDDIO pfet L=0.13U W=2U
Mtx_Mnr1p_f2 tx/NB DIN VDDIO VDDIO pfet L=0.13U W=2U
Mtx_Mnr1p_f3 tx/NB DIN VDDIO VDDIO pfet L=0.13U W=2U
Mtx_Mnr2p_f0 tx/GN tx/OEB tx/NB VDDIO pfet L=0.13U W=2U
Mtx_Mnr2p_f1 tx/GN tx/OEB tx/NB VDDIO pfet L=0.13U W=2U
Mtx_Mnr2p_f2 tx/GN tx/OEB tx/NB VDDIO pfet L=0.13U W=2U
Mtx_Mnr2p_f3 tx/GN tx/OEB tx/NB VDDIO pfet L=0.13U W=2U
Mtx_Mnr1n_f0 tx/GN DIN VSS VSS nfet L=0.13U W=1U
Mtx_Mnr1n_f1 tx/GN DIN VSS VSS nfet L=0.13U W=1U
Mtx_Mnr2n_f0 tx/GN tx/OEB VSS VSS nfet L=0.13U W=1U
Mtx_Mnr2n_f1 tx/GN tx/OEB VSS VSS nfet L=0.13U W=1U
Mtx_Mp_f0 tx/DP tx/GP VDDIO VDDIO pfet L=0.13U W=1U
Mtx_Mp_f1 tx/DP tx/GP VDDIO VDDIO pfet L=0.13U W=1U
Mtx_Mp_f2 tx/DP tx/GP VDDIO VDDIO pfet L=0.13U W=1U
Mtx_Mp_f3 tx/DP tx/GP VDDIO VDDIO pfet L=0.13U W=1U
Mtx_Mp_f4 tx/DP tx/GP VDDIO VDDIO pfet L=0.13U W=1U
Mtx_Mp_f5 tx/DP tx/GP VDDIO VDDIO pfet L=0.13U W=1U
Mtx_Mp_f6 tx/DP tx/GP VDDIO VDDIO pfet L=0.13U W=1U
Mtx_Mp_f7 tx/DP tx/GP VDDIO VDDIO pfet L=0.13U W=1U
Mtx_Mp_f8 tx/DP tx/GP VDDIO VDDIO pfet L=0.13U W=1U
Mtx_Mp_f9 tx/DP tx/GP VDDIO VDDIO pfet L=0.13U W=1U
Mtx_Mp_f10 tx/DP tx/GP VDDIO VDDIO pfet L=0.13U W=1U
Mtx_Mp_f11 tx/DP tx/GP VDDIO VDDIO pfet L=0.13U W=1U
Mtx_Mp_f12 tx/DP tx/GP VDDIO VDDIO pfet L=0.13U W=1U
Mtx_Mp_f13 tx/DP tx/GP VDDIO VDDIO pfet L=0.13U W=1U
Mtx_Mp_f14 tx/DP tx/GP VDDIO VDDIO pfet L=0.13U W=1U
Mtx_Mp_f15 tx/DP tx/GP VDDIO VDDIO pfet L=0.13U W=1U
Mtx_Mp_f16 tx/DP tx/GP VDDIO VDDIO pfet L=0.13U W=1U
Mtx_Mp_f17 tx/DP tx/GP VDDIO VDDIO pfet L=0.13U W=1U
Mtx_Mp_f18 tx/DP tx/GP VDDIO VDDIO pfet L=0.13U W=1U
Mtx_Mp_f19 tx/DP tx/GP VDDIO VDDIO pfet L=0.13U W=1U
Mtx_Mp_f20 tx/DP tx/GP VDDIO VDDIO pfet L=0.13U W=1U
Mtx_Mp_f21 tx/DP tx/GP VDDIO VDDIO pfet L=0.13U W=1U
Mtx_Mp_f22 tx/DP tx/GP VDDIO VDDIO pfet L=0.13U W=1U
Mtx_Mp_f23 tx/DP tx/GP VDDIO VDDIO pfet L=0.13U W=1U
Mtx_Mp_f24 tx/DP tx/GP VDDIO VDDIO pfet L=0.13U W=1U
Mtx_Mp_f25 tx/DP tx/GP VDDIO VDDIO pfet L=0.13U W=1U
Mtx_Mp_f26 tx/DP tx/GP VDDIO VDDIO pfet L=0.13U W=1U
Mtx_Mp_f27 tx/DP tx/GP VDDIO VDDIO pfet L=0.13U W=1U
Mtx_Mp_f28 tx/DP tx/GP VDDIO VDDIO pfet L=0.13U W=1U
Mtx_Mp_f29 tx/DP tx/GP VDDIO VDDIO pfet L=0.13U W=1U
Mtx_Mp_f30 tx/DP tx/GP VDDIO VDDIO pfet L=0.13U W=1U
Mtx_Mp_f31 tx/DP tx/GP VDDIO VDDIO pfet L=0.13U W=1U
Mtx_Mp_f32 tx/DP tx/GP VDDIO VDDIO pfet L=0.13U W=1U
Mtx_Mp_f33 tx/DP tx/GP VDDIO VDDIO pfet L=0.13U W=1U
Mtx_Mp_f34 tx/DP tx/GP VDDIO VDDIO pfet L=0.13U W=1U
Mtx_Mp_f35 tx/DP tx/GP VDDIO VDDIO pfet L=0.13U W=1U
Mtx_Mp_f36 tx/DP tx/GP VDDIO VDDIO pfet L=0.13U W=1U
Mtx_Mp_f37 tx/DP tx/GP VDDIO VDDIO pfet L=0.13U W=1U
Mtx_Mp_f38 tx/DP tx/GP VDDIO VDDIO pfet L=0.13U W=1U
Mtx_Mp_f39 tx/DP tx/GP VDDIO VDDIO pfet L=0.13U W=1U
Mtx_Mp_f40 tx/DP tx/GP VDDIO VDDIO pfet L=0.13U W=1U
Mtx_Mp_f41 tx/DP tx/GP VDDIO VDDIO pfet L=0.13U W=1U
Mtx_Mp_f42 tx/DP tx/GP VDDIO VDDIO pfet L=0.13U W=1U
Mtx_Mp_f43 tx/DP tx/GP VDDIO VDDIO pfet L=0.13U W=1U
Mtx_Mp_f44 tx/DP tx/GP VDDIO VDDIO pfet L=0.13U W=1U
Mtx_Mp_f45 tx/DP tx/GP VDDIO VDDIO pfet L=0.13U W=1U
Mtx_Mp_f46 tx/DP tx/GP VDDIO VDDIO pfet L=0.13U W=1U
Mtx_Mp_f47 tx/DP tx/GP VDDIO VDDIO pfet L=0.13U W=1U
Mtx_Mp_f48 tx/DP tx/GP VDDIO VDDIO pfet L=0.13U W=1U
Mtx_Mp_f49 tx/DP tx/GP VDDIO VDDIO pfet L=0.13U W=1U
Mtx_Mp_f50 tx/DP tx/GP VDDIO VDDIO pfet L=0.13U W=1U
Mtx_Mp_f51 tx/DP tx/GP VDDIO VDDIO pfet L=0.13U W=1U
Mtx_Mp_f52 tx/DP tx/GP VDDIO VDDIO pfet L=0.13U W=1U
Mtx_Mp_f53 tx/DP tx/GP VDDIO VDDIO pfet L=0.13U W=1U
Mtx_Mn_f0 tx/DN tx/GN VSS VSS nfet L=0.13U W=1U
Mtx_Mn_f1 tx/DN tx/GN VSS VSS nfet L=0.13U W=1U
Mtx_Mn_f2 tx/DN tx/GN VSS VSS nfet L=0.13U W=1U
Mtx_Mn_f3 tx/DN tx/GN VSS VSS nfet L=0.13U W=1U
Mtx_Mn_f4 tx/DN tx/GN VSS VSS nfet L=0.13U W=1U
Mtx_Mn_f5 tx/DN tx/GN VSS VSS nfet L=0.13U W=1U
Mtx_Mn_f6 tx/DN tx/GN VSS VSS nfet L=0.13U W=1U
Mtx_Mn_f7 tx/DN tx/GN VSS VSS nfet L=0.13U W=1U
Mtx_Mn_f8 tx/DN tx/GN VSS VSS nfet L=0.13U W=1U
Mtx_Mn_f9 tx/DN tx/GN VSS VSS nfet L=0.13U W=1U
Mtx_Mn_f10 tx/DN tx/GN VSS VSS nfet L=0.13U W=1U
Mtx_Mn_f11 tx/DN tx/GN VSS VSS nfet L=0.13U W=1U
Mtx_Mn_f12 tx/DN tx/GN VSS VSS nfet L=0.13U W=1U
Mtx_Mn_f13 tx/DN tx/GN VSS VSS nfet L=0.13U W=1U
Mtx_Mn_f14 tx/DN tx/GN VSS VSS nfet L=0.13U W=1U
Mtx_Mn_f15 tx/DN tx/GN VSS VSS nfet L=0.13U W=1U
Mtx_Mn_f16 tx/DN tx/GN VSS VSS nfet L=0.13U W=1U
Mtx_Mn_f17 tx/DN tx/GN VSS VSS nfet L=0.13U W=1U
Mtx_Mn_f18 tx/DN tx/GN VSS VSS nfet L=0.13U W=1U
Mtx_Mn_f19 tx/DN tx/GN VSS VSS nfet L=0.13U W=1U
Mtx_Mn_f20 tx/DN tx/GN VSS VSS nfet L=0.13U W=1U
Mtx_Mn_f21 tx/DN tx/GN VSS VSS nfet L=0.13U W=1U
Mtx_Mpu_f0 tx/PUX PUN VDDIO VDDIO pfet L=0.13U W=2U
Xtx_Rpu tx/PUX PAD VSS rppd r=12472.0 L=24U W=0.5U
Mtx_Mpd_f0 tx/PDX PD VSS VSS nfet L=0.13U W=1U
Xtx_Rpd PAD tx/PDX VSS rppd r=12472.0 L=24U W=0.5U
Xtx_Rsp tx/DP PAD VSS rppd r=20.0 L=0.5U W=10U
Xtx_Rsn tx/DN PAD VSS rppd r=20.0 L=0.5U W=10U
.ENDS
