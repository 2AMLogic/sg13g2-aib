* Generated by layout/lvs/gen_reference.py -- DO NOT EDIT BY HAND.
* Plain-element form for `klt lvs`; flattened from the item 1 netlists:
*   design/aib_pad_esd.spice sha256:78e223623f816e37dcb6735de42bb35d93675dd5a8c023ab0a56b1d864d3c83e
*   design/aib_tx_data.spice sha256:c24baff6ba4ce141d2c587bd1581746be8b3ccf1c10f5209a0ea8937446f945d
*   design/aib_rx_data.spice sha256:43f326de980bc5a817d6235ab5402de4aa02886619ead25e7e60c41dfef99eab
*   design/aib_tx_clk.spice sha256:a1b8b12ee92fcbcb4746868f2f21ef8c5dc437fd33854036039468095f474cdd
*   design/aib_rx_clk.spice sha256:0e53de36f4d0d2585452746bb2cb5d35e7c8b0801cdf597efe1dbb7bc01b5b2d
.SUBCKT aib_io_tx DIN OE PAD PD PUN VDDIO VSS
Desd_Dp1 PAD VDDIO dpantenna A=20.25P P=18U
Mesd_Mn1_f0 PAD VSS VSS VSS nfet L=0.13U W=2U
Mesd_Mn1_f1 PAD VSS VSS VSS nfet L=0.13U W=2U
Mesd_Mn1_f2 PAD VSS VSS VSS nfet L=0.13U W=2U
Mesd_Mn1_f3 PAD VSS VSS VSS nfet L=0.13U W=2U
Mesd_Mn1_f4 PAD VSS VSS VSS nfet L=0.13U W=2U
Mesd_Mn1_f5 PAD VSS VSS VSS nfet L=0.13U W=2U
Mesd_Mn1_f6 PAD VSS VSS VSS nfet L=0.13U W=2U
Mesd_Mn1_f7 PAD VSS VSS VSS nfet L=0.13U W=2U
Mesd_Mn1_f8 PAD VSS VSS VSS nfet L=0.13U W=2U
Mesd_Mn1_f9 PAD VSS VSS VSS nfet L=0.13U W=2U
Mesd_Mclamp_f0 VDDIO VSS VSS VSS nfet L=0.35U W=2U
Mesd_Mclamp_f1 VDDIO VSS VSS VSS nfet L=0.35U W=2U
Mesd_Mclamp_f2 VDDIO VSS VSS VSS nfet L=0.35U W=2U
Mesd_Mclamp_f3 VDDIO VSS VSS VSS nfet L=0.35U W=2U
Mesd_Mclamp_f4 VDDIO VSS VSS VSS nfet L=0.35U W=2U
Mesd_Mclamp_f5 VDDIO VSS VSS VSS nfet L=0.35U W=2U
Mesd_Mclamp_f6 VDDIO VSS VSS VSS nfet L=0.35U W=2U
Mesd_Mclamp_f7 VDDIO VSS VSS VSS nfet L=0.35U W=2U
Mesd_Mclamp_f8 VDDIO VSS VSS VSS nfet L=0.35U W=2U
Mesd_Mclamp_f9 VDDIO VSS VSS VSS nfet L=0.35U W=2U
Mesd_Mclamp_f10 VDDIO VSS VSS VSS nfet L=0.35U W=2U
Mesd_Mclamp_f11 VDDIO VSS VSS VSS nfet L=0.35U W=2U
Mesd_Mclamp_f12 VDDIO VSS VSS VSS nfet L=0.35U W=2U
Mesd_Mclamp_f13 VDDIO VSS VSS VSS nfet L=0.35U W=2U
Mesd_Mclamp_f14 VDDIO VSS VSS VSS nfet L=0.35U W=2U
Mesd_Mclamp_f15 VDDIO VSS VSS VSS nfet L=0.35U W=2U
Mesd_Mclamp_f16 VDDIO VSS VSS VSS nfet L=0.35U W=2U
Mesd_Mclamp_f17 VDDIO VSS VSS VSS nfet L=0.35U W=2U
Mesd_Mclamp_f18 VDDIO VSS VSS VSS nfet L=0.35U W=2U
Mesd_Mclamp_f19 VDDIO VSS VSS VSS nfet L=0.35U W=2U
Xesd_Resd PAD PADI VSS rppd r=294.2 L=2U W=2U
Desd_Dp2 PADI VDDIO dpantenna A=4P P=8U
Mesd_Mn2_f0 PADI VSS VSS VSS nfet L=0.13U W=1U
Mtx_Mi1p_f0 tx/OEB OE VDDIO VDDIO pfet L=0.13U W=2U
Mtx_Mi1n_f0 tx/OEB OE VSS VSS nfet L=0.13U W=1U
Mtx_Mnd1p_f0 tx/GP DIN VDDIO VDDIO pfet L=0.13U W=2U
Mtx_Mnd1p_f1 tx/GP DIN VDDIO VDDIO pfet L=0.13U W=2U
Mtx_Mnd2p_f0 tx/GP OE VDDIO VDDIO pfet L=0.13U W=2U
Mtx_Mnd2p_f1 tx/GP OE VDDIO VDDIO pfet L=0.13U W=2U
Mtx_Mnd1n_f0 tx/GP DIN tx/NA VSS nfet L=0.13U W=2U
Mtx_Mnd1n_f1 tx/GP DIN tx/NA VSS nfet L=0.13U W=2U
Mtx_Mnd2n_f0 tx/NA OE VSS VSS nfet L=0.13U W=2U
Mtx_Mnd2n_f1 tx/NA OE VSS VSS nfet L=0.13U W=2U
Mtx_Mnr1p_f0 tx/NB DIN VDDIO VDDIO pfet L=0.13U W=2U
Mtx_Mnr1p_f1 tx/NB DIN VDDIO VDDIO pfet L=0.13U W=2U
Mtx_Mnr2p_f0 tx/GN tx/OEB tx/NB VDDIO pfet L=0.13U W=2U
Mtx_Mnr2p_f1 tx/GN tx/OEB tx/NB VDDIO pfet L=0.13U W=2U
Mtx_Mnr1n_f0 tx/GN DIN VSS VSS nfet L=0.13U W=1U
Mtx_Mnr1n_f1 tx/GN DIN VSS VSS nfet L=0.13U W=1U
Mtx_Mnr2n_f0 tx/GN tx/OEB VSS VSS nfet L=0.13U W=1U
Mtx_Mnr2n_f1 tx/GN tx/OEB VSS VSS nfet L=0.13U W=1U
Mtx_Mp_f0 tx/DP tx/GP VDDIO VDDIO pfet L=0.13U W=1U
Mtx_Mp_f1 tx/DP tx/GP VDDIO VDDIO pfet L=0.13U W=1U
Mtx_Mp_f2 tx/DP tx/GP VDDIO VDDIO pfet L=0.13U W=1U
Mtx_Mp_f3 tx/DP tx/GP VDDIO VDDIO pfet L=0.13U W=1U
Mtx_Mp_f4 tx/DP tx/GP VDDIO VDDIO pfet L=0.13U W=1U
Mtx_Mp_f5 tx/DP tx/GP VDDIO VDDIO pfet L=0.13U W=1U
Mtx_Mp_f6 tx/DP tx/GP VDDIO VDDIO pfet L=0.13U W=1U
Mtx_Mp_f7 tx/DP tx/GP VDDIO VDDIO pfet L=0.13U W=1U
Mtx_Mp_f8 tx/DP tx/GP VDDIO VDDIO pfet L=0.13U W=1U
Mtx_Mp_f9 tx/DP tx/GP VDDIO VDDIO pfet L=0.13U W=1U
Mtx_Mp_f10 tx/DP tx/GP VDDIO VDDIO pfet L=0.13U W=1U
Mtx_Mp_f11 tx/DP tx/GP VDDIO VDDIO pfet L=0.13U W=1U
Mtx_Mp_f12 tx/DP tx/GP VDDIO VDDIO pfet L=0.13U W=1U
Mtx_Mp_f13 tx/DP tx/GP VDDIO VDDIO pfet L=0.13U W=1U
Mtx_Mp_f14 tx/DP tx/GP VDDIO VDDIO pfet L=0.13U W=1U
Mtx_Mp_f15 tx/DP tx/GP VDDIO VDDIO pfet L=0.13U W=1U
Mtx_Mp_f16 tx/DP tx/GP VDDIO VDDIO pfet L=0.13U W=1U
Mtx_Mp_f17 tx/DP tx/GP VDDIO VDDIO pfet L=0.13U W=1U
Mtx_Mp_f18 tx/DP tx/GP VDDIO VDDIO pfet L=0.13U W=1U
Mtx_Mp_f19 tx/DP tx/GP VDDIO VDDIO pfet L=0.13U W=1U
Mtx_Mp_f20 tx/DP tx/GP VDDIO VDDIO pfet L=0.13U W=1U
Mtx_Mp_f21 tx/DP tx/GP VDDIO VDDIO pfet L=0.13U W=1U
Mtx_Mp_f22 tx/DP tx/GP VDDIO VDDIO pfet L=0.13U W=1U
Mtx_Mp_f23 tx/DP tx/GP VDDIO VDDIO pfet L=0.13U W=1U
Mtx_Mp_f24 tx/DP tx/GP VDDIO VDDIO pfet L=0.13U W=1U
Mtx_Mp_f25 tx/DP tx/GP VDDIO VDDIO pfet L=0.13U W=1U
Mtx_Mp_f26 tx/DP tx/GP VDDIO VDDIO pfet L=0.13U W=1U
Mtx_Mp_f27 tx/DP tx/GP VDDIO VDDIO pfet L=0.13U W=1U
Mtx_Mp_f28 tx/DP tx/GP VDDIO VDDIO pfet L=0.13U W=1U
Mtx_Mp_f29 tx/DP tx/GP VDDIO VDDIO pfet L=0.13U W=1U
Mtx_Mp_f30 tx/DP tx/GP VDDIO VDDIO pfet L=0.13U W=1U
Mtx_Mp_f31 tx/DP tx/GP VDDIO VDDIO pfet L=0.13U W=1U
Mtx_Mp_f32 tx/DP tx/GP VDDIO VDDIO pfet L=0.13U W=1U
Mtx_Mp_f33 tx/DP tx/GP VDDIO VDDIO pfet L=0.13U W=1U
Mtx_Mp_f34 tx/DP tx/GP VDDIO VDDIO pfet L=0.13U W=1U
Mtx_Mp_f35 tx/DP tx/GP VDDIO VDDIO pfet L=0.13U W=1U
Mtx_Mp_f36 tx/DP tx/GP VDDIO VDDIO pfet L=0.13U W=1U
Mtx_Mp_f37 tx/DP tx/GP VDDIO VDDIO pfet L=0.13U W=1U
Mtx_Mp_f38 tx/DP tx/GP VDDIO VDDIO pfet L=0.13U W=1U
Mtx_Mp_f39 tx/DP tx/GP VDDIO VDDIO pfet L=0.13U W=1U
Mtx_Mp_f40 tx/DP tx/GP VDDIO VDDIO pfet L=0.13U W=1U
Mtx_Mp_f41 tx/DP tx/GP VDDIO VDDIO pfet L=0.13U W=1U
Mtx_Mp_f42 tx/DP tx/GP VDDIO VDDIO pfet L=0.13U W=1U
Mtx_Mp_f43 tx/DP tx/GP VDDIO VDDIO pfet L=0.13U W=1U
Mtx_Mp_f44 tx/DP tx/GP VDDIO VDDIO pfet L=0.13U W=1U
Mtx_Mp_f45 tx/DP tx/GP VDDIO VDDIO pfet L=0.13U W=1U
Mtx_Mp_f46 tx/DP tx/GP VDDIO VDDIO pfet L=0.13U W=1U
Mtx_Mp_f47 tx/DP tx/GP VDDIO VDDIO pfet L=0.13U W=1U
Mtx_Mp_f48 tx/DP tx/GP VDDIO VDDIO pfet L=0.13U W=1U
Mtx_Mp_f49 tx/DP tx/GP VDDIO VDDIO pfet L=0.13U W=1U
Mtx_Mp_f50 tx/DP tx/GP VDDIO VDDIO pfet L=0.13U W=1U
Mtx_Mp_f51 tx/DP tx/GP VDDIO VDDIO pfet L=0.13U W=1U
Mtx_Mp_f52 tx/DP tx/GP VDDIO VDDIO pfet L=0.13U W=1U
Mtx_Mp_f53 tx/DP tx/GP VDDIO VDDIO pfet L=0.13U W=1U
Mtx_Mn_f0 tx/DN tx/GN VSS VSS nfet L=0.13U W=1U
Mtx_Mn_f1 tx/DN tx/GN VSS VSS nfet L=0.13U W=1U
Mtx_Mn_f2 tx/DN tx/GN VSS VSS nfet L=0.13U W=1U
Mtx_Mn_f3 tx/DN tx/GN VSS VSS nfet L=0.13U W=1U
Mtx_Mn_f4 tx/DN tx/GN VSS VSS nfet L=0.13U W=1U
Mtx_Mn_f5 tx/DN tx/GN VSS VSS nfet L=0.13U W=1U
Mtx_Mn_f6 tx/DN tx/GN VSS VSS nfet L=0.13U W=1U
Mtx_Mn_f7 tx/DN tx/GN VSS VSS nfet L=0.13U W=1U
Mtx_Mn_f8 tx/DN tx/GN VSS VSS nfet L=0.13U W=1U
Mtx_Mn_f9 tx/DN tx/GN VSS VSS nfet L=0.13U W=1U
Mtx_Mn_f10 tx/DN tx/GN VSS VSS nfet L=0.13U W=1U
Mtx_Mn_f11 tx/DN tx/GN VSS VSS nfet L=0.13U W=1U
Mtx_Mn_f12 tx/DN tx/GN VSS VSS nfet L=0.13U W=1U
Mtx_Mn_f13 tx/DN tx/GN VSS VSS nfet L=0.13U W=1U
Mtx_Mn_f14 tx/DN tx/GN VSS VSS nfet L=0.13U W=1U
Mtx_Mn_f15 tx/DN tx/GN VSS VSS nfet L=0.13U W=1U
Mtx_Mn_f16 tx/DN tx/GN VSS VSS nfet L=0.13U W=1U
Mtx_Mn_f17 tx/DN tx/GN VSS VSS nfet L=0.13U W=1U
Mtx_Mn_f18 tx/DN tx/GN VSS VSS nfet L=0.13U W=1U
Mtx_Mn_f19 tx/DN tx/GN VSS VSS nfet L=0.13U W=1U
Mtx_Mn_f20 tx/DN tx/GN VSS VSS nfet L=0.13U W=1U
Mtx_Mn_f21 tx/DN tx/GN VSS VSS nfet L=0.13U W=1U
Mtx_Mpu_f0 tx/PUX PUN VDDIO VDDIO pfet L=0.13U W=2U
Xtx_Rpu tx/PUX PAD VSS rppd r=12472.0 L=24U W=0.5U
Mtx_Mpd_f0 tx/PDX PD VSS VSS nfet L=0.13U W=1U
Xtx_Rpd PAD tx/PDX VSS rppd r=12472.0 L=24U W=0.5U
Xtx_Rsp tx/DP PAD VSS rppd r=20.0 L=0.5U W=10U
Xtx_Rsn tx/DN PAD VSS rppd r=20.0 L=0.5U W=10U
.ENDS
