* Generated by layout/lvs/gen_reference.py -- DO NOT EDIT BY HAND.
* Plain-element form for `klt lvs`; flattened from the item 1 netlists:
*   design/aib_pad_esd.spice sha256:3cb704eb07544c97702c141626fe54285850dfc17a7ca20932c3bc24c6609489
*   design/aib_tx_data.spice sha256:667c53139825da4804873cab2f2038c4576063c466dfb9ce16c1a9a527bbf545
*   design/aib_rx_data.spice sha256:7863828c03ab4412c465be9931b6f8172fc90fe572ec64c72c4bb36cc34d6774
*   design/aib_rx_inv.spice sha256:8cd42264f8014ff28951be5fb52e9ed94fadb94b89fc99aba5291e6d6b8b90fe
*   design/aib_tx_clk.spice sha256:35de4d0bc6f1ad109c1477efa0cde485ae7a39f1b90005e92a2a0fd7db55e248
*   design/aib_rx_clk.spice sha256:3675d8bb85f776fda07a1183adfd3b846062bd034c49d054a4f905cf58a95bb7
.SUBCKT aib_io_rx DOUT PAD VDDIO VSS
Desd_Dp1 PAD VDDIO diodevdd_mod A=35P P=58.08U
Desd_Dp1_dsub VSS VDDIO dsub_2kv_mod A=224.956P P=81.12U
Mesd_Mn1_f0 PAD VSS VSS VSS nfet L=0.13U W=2U
Mesd_Mn1_f1 PAD VSS VSS VSS nfet L=0.13U W=2U
Mesd_Mn1_f2 PAD VSS VSS VSS nfet L=0.13U W=2U
Mesd_Mn1_f3 PAD VSS VSS VSS nfet L=0.13U W=2U
Mesd_Mn1_f4 PAD VSS VSS VSS nfet L=0.13U W=2U
Mesd_Mn1_f5 PAD VSS VSS VSS nfet L=0.13U W=2U
Mesd_Mn1_f6 PAD VSS VSS VSS nfet L=0.13U W=2U
Mesd_Mn1_f7 PAD VSS VSS VSS nfet L=0.13U W=2U
Mesd_Mn1_f8 PAD VSS VSS VSS nfet L=0.13U W=2U
Mesd_Mn1_f9 PAD VSS VSS VSS nfet L=0.13U W=2U
Mesd_Mclamp_f0 VDDIO VSS VSS VSS nfet L=0.35U W=2U
Mesd_Mclamp_f1 VDDIO VSS VSS VSS nfet L=0.35U W=2U
Mesd_Mclamp_f2 VDDIO VSS VSS VSS nfet L=0.35U W=2U
Mesd_Mclamp_f3 VDDIO VSS VSS VSS nfet L=0.35U W=2U
Mesd_Mclamp_f4 VDDIO VSS VSS VSS nfet L=0.35U W=2U
Mesd_Mclamp_f5 VDDIO VSS VSS VSS nfet L=0.35U W=2U
Mesd_Mclamp_f6 VDDIO VSS VSS VSS nfet L=0.35U W=2U
Mesd_Mclamp_f7 VDDIO VSS VSS VSS nfet L=0.35U W=2U
Mesd_Mclamp_f8 VDDIO VSS VSS VSS nfet L=0.35U W=2U
Mesd_Mclamp_f9 VDDIO VSS VSS VSS nfet L=0.35U W=2U
Mesd_Mclamp_f10 VDDIO VSS VSS VSS nfet L=0.35U W=2U
Mesd_Mclamp_f11 VDDIO VSS VSS VSS nfet L=0.35U W=2U
Mesd_Mclamp_f12 VDDIO VSS VSS VSS nfet L=0.35U W=2U
Mesd_Mclamp_f13 VDDIO VSS VSS VSS nfet L=0.35U W=2U
Mesd_Mclamp_f14 VDDIO VSS VSS VSS nfet L=0.35U W=2U
Mesd_Mclamp_f15 VDDIO VSS VSS VSS nfet L=0.35U W=2U
Mesd_Mclamp_f16 VDDIO VSS VSS VSS nfet L=0.35U W=2U
Mesd_Mclamp_f17 VDDIO VSS VSS VSS nfet L=0.35U W=2U
Mesd_Mclamp_f18 VDDIO VSS VSS VSS nfet L=0.35U W=2U
Mesd_Mclamp_f19 VDDIO VSS VSS VSS nfet L=0.35U W=2U
Xesd_Resd PAD PADI VSS rppd r=164.6 L=1U W=2U
Desd_Dp2 PADI VDDIO dpantenna A=4P P=8U
Mesd_Mn2_f0 PADI VSS VSS VSS nfet L=0.13U W=1U
Xrx_Rdiv1 VDDIO rx/vrn VSS rppd r=24804.0 L=48U W=0.5U
Xrx_Rdiv2 rx/vrn VSS VSS rppd r=24804.0 L=48U W=0.5U
Mrx_Mtail_f0 rx/s1 VDDIO VSS VSS nfet L=0.5U W=1U
Mrx_Mtail_f1 rx/s1 VDDIO VSS VSS nfet L=0.5U W=1U
Mrx_Mnp_f0 rx/d1 PADI rx/s1 VSS nfet L=0.5U W=0.5U
Mrx_Mnp_f1 rx/d1 PADI rx/s1 VSS nfet L=0.5U W=0.5U
Mrx_Mnn_f0 rx/d2 rx/vrn rx/s1 VSS nfet L=0.5U W=0.5U
Mrx_Mnn_f1 rx/d2 rx/vrn rx/s1 VSS nfet L=0.5U W=0.5U
Mrx_Mlp_f0 rx/d2 rx/d2 VDDIO VDDIO pfet L=0.25U W=1U
Mrx_Mlp_f1 rx/d2 rx/d2 VDDIO VDDIO pfet L=0.25U W=1U
Mrx_Mlp_f2 rx/d2 rx/d2 VDDIO VDDIO pfet L=0.25U W=1U
Mrx_Mlp_f3 rx/d2 rx/d2 VDDIO VDDIO pfet L=0.25U W=1U
Mrx_Mln_f0 rx/d1 rx/d2 VDDIO VDDIO pfet L=0.25U W=1U
Mrx_Mln_f1 rx/d1 rx/d2 VDDIO VDDIO pfet L=0.25U W=1U
Mrx_Mln_f2 rx/d1 rx/d2 VDDIO VDDIO pfet L=0.25U W=1U
Mrx_Mln_f3 rx/d1 rx/d2 VDDIO VDDIO pfet L=0.25U W=1U
Mrx_Mi2p_f0 DOUT rx/d1 VDDIO VDDIO pfet L=0.13U W=2U
Mrx_Mi2n_f0 DOUT rx/d1 VSS VSS nfet L=0.13U W=1U
.ENDS
