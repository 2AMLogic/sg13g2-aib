* Generated by layout/lvs/gen_reference.py -- DO NOT EDIT BY HAND.
* Plain-element form for `klt lvs`; flattened from the item 1 netlists:
*   design/aib_pad_esd.spice sha256:86d410385d099254f0376b9b4638cd18dfee8e7ae538a45e2ed85e2cdea415d5
*   design/aib_tx_data.spice sha256:adf7d751f8645148fe68be97b8d1ade38a2eadbf5432e05eed059c570850d2d7
*   design/aib_rx_data.spice sha256:43f326de980bc5a817d6235ab5402de4aa02886619ead25e7e60c41dfef99eab
*   design/aib_tx_clk.spice sha256:d2bdf119e914678106c566674093ccc54b75174d76592851cfd98db57dce32ad
*   design/aib_rx_clk.spice sha256:0e53de36f4d0d2585452746bb2cb5d35e7c8b0801cdf597efe1dbb7bc01b5b2d
.SUBCKT aib_io_rx DOUT PAD VDDIO VSS
Desd_Dp1 PAD VDDIO dpantenna A=100P P=40U
Desd_Dn1 VSS PAD dantenna A=100P P=40U
Mesd_Mclamp_f0 VDDIO VSS VSS VSS nfet L=0.35U W=2U
Mesd_Mclamp_f1 VDDIO VSS VSS VSS nfet L=0.35U W=2U
Mesd_Mclamp_f2 VDDIO VSS VSS VSS nfet L=0.35U W=2U
Mesd_Mclamp_f3 VDDIO VSS VSS VSS nfet L=0.35U W=2U
Mesd_Mclamp_f4 VDDIO VSS VSS VSS nfet L=0.35U W=2U
Mesd_Mclamp_f5 VDDIO VSS VSS VSS nfet L=0.35U W=2U
Mesd_Mclamp_f6 VDDIO VSS VSS VSS nfet L=0.35U W=2U
Mesd_Mclamp_f7 VDDIO VSS VSS VSS nfet L=0.35U W=2U
Mesd_Mclamp_f8 VDDIO VSS VSS VSS nfet L=0.35U W=2U
Mesd_Mclamp_f9 VDDIO VSS VSS VSS nfet L=0.35U W=2U
Mesd_Mclamp_f10 VDDIO VSS VSS VSS nfet L=0.35U W=2U
Mesd_Mclamp_f11 VDDIO VSS VSS VSS nfet L=0.35U W=2U
Mesd_Mclamp_f12 VDDIO VSS VSS VSS nfet L=0.35U W=2U
Mesd_Mclamp_f13 VDDIO VSS VSS VSS nfet L=0.35U W=2U
Mesd_Mclamp_f14 VDDIO VSS VSS VSS nfet L=0.35U W=2U
Mesd_Mclamp_f15 VDDIO VSS VSS VSS nfet L=0.35U W=2U
Mesd_Mclamp_f16 VDDIO VSS VSS VSS nfet L=0.35U W=2U
Mesd_Mclamp_f17 VDDIO VSS VSS VSS nfet L=0.35U W=2U
Mesd_Mclamp_f18 VDDIO VSS VSS VSS nfet L=0.35U W=2U
Mesd_Mclamp_f19 VDDIO VSS VSS VSS nfet L=0.35U W=2U
Xesd_Resd PAD PADI VSS rppd r=294.2 L=2U W=2U
Desd_Dp2 PADI VDDIO dpantenna A=4P P=8U
Mesd_Mn2_f0 PADI VSS VSS VSS nfet L=0.13U W=1U
Mrx_Mi1p_f0 rx/M1 PADI VDDIO VDDIO pfet L=0.13U W=1.25U
Mrx_Mi1p_f1 rx/M1 PADI VDDIO VDDIO pfet L=0.13U W=1.25U
Mrx_Mi1n_f0 rx/M1 PADI VSS VSS nfet L=0.13U W=0.5U
Mrx_Mi1n_f1 rx/M1 PADI VSS VSS nfet L=0.13U W=0.5U
Mrx_Mi2p_f0 DOUT rx/M1 VDDIO VDDIO pfet L=0.13U W=2U
Mrx_Mi2p_f1 DOUT rx/M1 VDDIO VDDIO pfet L=0.13U W=2U
Mrx_Mi2n_f0 DOUT rx/M1 VSS VSS nfet L=0.13U W=1U
Mrx_Mi2n_f1 DOUT rx/M1 VSS VSS nfet L=0.13U W=1U
.ENDS
