* Generated by layout/lvs/gen_reference.py -- DO NOT EDIT BY HAND.
* Plain-element form for `klt lvs`; flattened from the item 1 netlists:
*   design/aib_pad_esd.spice sha256:3cb704eb07544c97702c141626fe54285850dfc17a7ca20932c3bc24c6609489
*   design/aib_tx_data.spice sha256:667c53139825da4804873cab2f2038c4576063c466dfb9ce16c1a9a527bbf545
*   design/aib_rx_data.spice sha256:43f326de980bc5a817d6235ab5402de4aa02886619ead25e7e60c41dfef99eab
*   design/aib_tx_clk.spice sha256:35de4d0bc6f1ad109c1477efa0cde485ae7a39f1b90005e92a2a0fd7db55e248
*   design/aib_rx_clk.spice sha256:0e53de36f4d0d2585452746bb2cb5d35e7c8b0801cdf597efe1dbb7bc01b5b2d
.SUBCKT aib_io_rx DOUT PAD VDDIO VSS
Desd_Dp1 PAD VDDIO diodevdd_mod A=35P P=58.08U
Desd_Dp1_dsub VSS VDDIO dsub_2kv_mod A=224.956P P=81.12U
Mesd_Mn1_f0 PAD VSS VSS VSS nfet L=0.13U W=2U
Mesd_Mn1_f1 PAD VSS VSS VSS nfet L=0.13U W=2U
Mesd_Mn1_f2 PAD VSS VSS VSS nfet L=0.13U W=2U
Mesd_Mn1_f3 PAD VSS VSS VSS nfet L=0.13U W=2U
Mesd_Mn1_f4 PAD VSS VSS VSS nfet L=0.13U W=2U
Mesd_Mn1_f5 PAD VSS VSS VSS nfet L=0.13U W=2U
Mesd_Mn1_f6 PAD VSS VSS VSS nfet L=0.13U W=2U
Mesd_Mn1_f7 PAD VSS VSS VSS nfet L=0.13U W=2U
Mesd_Mn1_f8 PAD VSS VSS VSS nfet L=0.13U W=2U
Mesd_Mn1_f9 PAD VSS VSS VSS nfet L=0.13U W=2U
Mesd_Mclamp_f0 VDDIO VSS VSS VSS nfet L=0.35U W=2U
Mesd_Mclamp_f1 VDDIO VSS VSS VSS nfet L=0.35U W=2U
Mesd_Mclamp_f2 VDDIO VSS VSS VSS nfet L=0.35U W=2U
Mesd_Mclamp_f3 VDDIO VSS VSS VSS nfet L=0.35U W=2U
Mesd_Mclamp_f4 VDDIO VSS VSS VSS nfet L=0.35U W=2U
Mesd_Mclamp_f5 VDDIO VSS VSS VSS nfet L=0.35U W=2U
Mesd_Mclamp_f6 VDDIO VSS VSS VSS nfet L=0.35U W=2U
Mesd_Mclamp_f7 VDDIO VSS VSS VSS nfet L=0.35U W=2U
Mesd_Mclamp_f8 VDDIO VSS VSS VSS nfet L=0.35U W=2U
Mesd_Mclamp_f9 VDDIO VSS VSS VSS nfet L=0.35U W=2U
Mesd_Mclamp_f10 VDDIO VSS VSS VSS nfet L=0.35U W=2U
Mesd_Mclamp_f11 VDDIO VSS VSS VSS nfet L=0.35U W=2U
Mesd_Mclamp_f12 VDDIO VSS VSS VSS nfet L=0.35U W=2U
Mesd_Mclamp_f13 VDDIO VSS VSS VSS nfet L=0.35U W=2U
Mesd_Mclamp_f14 VDDIO VSS VSS VSS nfet L=0.35U W=2U
Mesd_Mclamp_f15 VDDIO VSS VSS VSS nfet L=0.35U W=2U
Mesd_Mclamp_f16 VDDIO VSS VSS VSS nfet L=0.35U W=2U
Mesd_Mclamp_f17 VDDIO VSS VSS VSS nfet L=0.35U W=2U
Mesd_Mclamp_f18 VDDIO VSS VSS VSS nfet L=0.35U W=2U
Mesd_Mclamp_f19 VDDIO VSS VSS VSS nfet L=0.35U W=2U
Xesd_Resd PAD PADI VSS rppd r=164.6 L=1U W=2U
Desd_Dp2 PADI VDDIO dpantenna A=4P P=8U
Mesd_Mn2_f0 PADI VSS VSS VSS nfet L=0.13U W=1U
Mrx_Mi1p_f0 rx/M1 PADI VDDIO VDDIO pfet L=0.13U W=1.25U
Mrx_Mi1p_f1 rx/M1 PADI VDDIO VDDIO pfet L=0.13U W=1.25U
Mrx_Mi1n_f0 rx/M1 PADI VSS VSS nfet L=0.13U W=0.5U
Mrx_Mi1n_f1 rx/M1 PADI VSS VSS nfet L=0.13U W=0.5U
Mrx_Mi2p_f0 DOUT rx/M1 VDDIO VDDIO pfet L=0.13U W=2U
Mrx_Mi2p_f1 DOUT rx/M1 VDDIO VDDIO pfet L=0.13U W=2U
Mrx_Mi2n_f0 DOUT rx/M1 VSS VSS nfet L=0.13U W=1U
Mrx_Mi2n_f1 DOUT rx/M1 VSS VSS nfet L=0.13U W=1U
.ENDS
