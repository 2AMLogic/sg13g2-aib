* Generated by layout/pex/gen_pex_benches.py -- DO NOT EDIT BY HAND.
* Simulatable assembly of the drawn cell aib_io_tx, for the schematic leg of
* `klt pex` (T1 item 7, analog). Pin list and order are those of
* layout/lvs/aib_io_tx.ref.spice, the LVS-`match` reference for this cell.
* Built from the item 1 netlists, whose text is inlined verbatim below:
*   design/aib_pad_esd.spice sha256:78e223623f816e37dcb6735de42bb35d93675dd5a8c023ab0a56b1d864d3c83e
*   design/aib_tx_data.spice sha256:667c53139825da4804873cab2f2038c4576063c466dfb9ce16c1a9a527bbf545
.subckt aib_io_tx DIN OE PAD PD PUN VDDIO VSS
Xesd PAD PADI VDDIO VSS aib_pad_esd
Xtx DIN OE PUN PD PAD VDDIO VSS aib_tx_data
.ends
** sch_path: design/aib_pad_esd.sch
.subckt aib_pad_esd PAD PADI VDDIO VSS
*.PININFO PAD:B PADI:B VDDIO:B VSS:B
XDp1 PAD VDDIO dpantenna l=4.5u w=4.5u
XMn1 PAD VSS VSS VSS sg13_lv_nmos w=20u l=0.13u ng=10 m=1
XMclamp VDDIO VSS VSS VSS sg13_lv_nmos w=40u l=0.35u ng=20 m=1
XResd PAD PADI VSS rppd w=2u l=2u m=1 b=0
XDp2 PADI VDDIO dpantenna l=2u w=2u
XMn2 PADI VSS VSS VSS sg13_lv_nmos w=1u l=0.13u ng=1 m=1
.ends
** sch_path: design/aib_tx_data.sch
.subckt aib_tx_data DIN OE PUN PD PAD VDDIO VSS
*.PININFO DIN:I OE:I PUN:I PD:I PAD:B VDDIO:B VSS:B
XMi1p OEB OE VDDIO VDDIO sg13_lv_pmos w=2u l=0.13u ng=1 m=1
XMi1n OEB OE VSS VSS sg13_lv_nmos w=1u l=0.13u ng=1 m=1
XMnd1p GP DIN VDDIO VDDIO sg13_lv_pmos w=4u l=0.13u ng=2 m=1
XMnd2p GP OE VDDIO VDDIO sg13_lv_pmos w=4u l=0.13u ng=2 m=1
XMnd1n GP DIN NA VSS sg13_lv_nmos w=4u l=0.13u ng=2 m=1
XMnd2n NA OE VSS VSS sg13_lv_nmos w=4u l=0.13u ng=2 m=1
XMnr1p NB DIN VDDIO VDDIO sg13_lv_pmos w=8u l=0.13u ng=4 m=1
XMnr2p GN OEB NB VDDIO sg13_lv_pmos w=8u l=0.13u ng=4 m=1
XMnr1n GN DIN VSS VSS sg13_lv_nmos w=2u l=0.13u ng=2 m=1
XMnr2n GN OEB VSS VSS sg13_lv_nmos w=2u l=0.13u ng=2 m=1
XMp DP GP VDDIO VDDIO sg13_lv_pmos w=54u l=0.13u ng=54 m=1
XMn DN GN VSS VSS sg13_lv_nmos w=22u l=0.13u ng=22 m=1
XMpu PUX PUN VDDIO VDDIO sg13_lv_pmos w=2u l=0.13u ng=1 m=1
XRpu PUX PAD VSS rppd w=0.5u l=24u m=1 b=0
XMpd PDX PD VSS VSS sg13_lv_nmos w=1u l=0.13u ng=1 m=1
XRpd PAD PDX VSS rppd w=0.5u l=24u m=1 b=0
XRsp DP PAD VSS rppd w=10u l=0.5u m=1 b=0
XRsn DN PAD VSS rppd w=10u l=0.5u m=1 b=0
.ends
