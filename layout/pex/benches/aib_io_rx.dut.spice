* Generated by layout/pex/gen_pex_benches.py -- DO NOT EDIT BY HAND.
* Simulatable assembly of the drawn cell aib_io_rx, for the schematic leg of
* `klt pex` (T1 item 7, analog). Pin list and order are those of
* layout/lvs/aib_io_rx.ref.spice, the LVS-`match` reference for this cell.
* Built from the item 1 netlists, whose text is inlined verbatim below:
*   design/aib_pad_esd.spice sha256:4de31ffa56155c2f3dcdde64c4441578c565894baa765ae79972da43a5a51936
*   design/aib_rx_data.spice sha256:7863828c03ab4412c465be9931b6f8172fc90fe572ec64c72c4bb36cc34d6774
.subckt aib_io_rx DOUT PAD VDDIO VSS
Xesd PAD PADI VDDIO VSS aib_pad_esd
Xrx PADI DOUT VDDIO VSS aib_rx_data
.ends
** sch_path: design/aib_pad_esd.sch
.subckt aib_pad_esd PAD PADI VDDIO VSS
*.PININFO PAD:B PADI:B VDDIO:B VSS:B
XDp1 PAD VDDIO dpantenna l=4.5u w=4.5u
XMn1 PAD VSS VSS VSS sg13_lv_nmos w=20u l=0.13u ng=10 m=1
XMclamp VDDIO VSS VSS VSS sg13_lv_nmos w=40u l=0.35u ng=20 m=1
XResd PAD PADI VSS rppd w=2u l=1u m=1 b=0
XDp2 PADI VDDIO dpantenna l=2u w=2u
XMn2 PADI VSS VSS VSS sg13_lv_nmos w=1u l=0.13u ng=1 m=1
.ends
** klt-netlist-inputs: {"pdk_variant": "ihp-sg13g2", "rcfile": "xschemrc", "xschem_version": "3.4.7"}
** sch_path: design/aib_rx_data.sch
.subckt aib_rx_data PAD DOUT VDDIO VSS
*.PININFO PAD:I DOUT:O VDDIO:B VSS:B
XRdiv1 VDDIO vrn VSS rppd w=0.5u l=48u m=1 b=0
XRdiv2 vrn VSS VSS rppd w=0.5u l=48u m=1 b=0
XMtail s1 VDDIO VSS VSS sg13_lv_nmos w=2u l=0.5u ng=2 m=1
XMnp d1 PAD s1 VSS sg13_lv_nmos w=1u l=0.5u ng=2 m=1
XMnn d2 vrn s1 VSS sg13_lv_nmos w=1u l=0.5u ng=2 m=1
XMlp d2 d2 VDDIO VDDIO sg13_lv_pmos w=4u l=0.25u ng=4 m=1
XMln d1 d2 VDDIO VDDIO sg13_lv_pmos w=4u l=0.25u ng=4 m=1
XMi2p DOUT d1 VDDIO VDDIO sg13_lv_pmos w=2u l=0.13u ng=1 m=1
XMi2n DOUT d1 VSS VSS sg13_lv_nmos w=1u l=0.13u ng=1 m=1
.ends
