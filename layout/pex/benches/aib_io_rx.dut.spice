* Generated by layout/pex/gen_pex_benches.py -- DO NOT EDIT BY HAND.
* Simulatable assembly of the drawn cell aib_io_rx, for the schematic leg of
* `klt pex` (T1 item 7, analog). Pin list and order are those of
* layout/lvs/aib_io_rx.ref.spice, the LVS-`match` reference for this cell.
* Built from the item 1 netlists, whose text is inlined verbatim below:
*   design/aib_pad_esd.spice sha256:3cb704eb07544c97702c141626fe54285850dfc17a7ca20932c3bc24c6609489
*   design/aib_rx_data.spice sha256:43f326de980bc5a817d6235ab5402de4aa02886619ead25e7e60c41dfef99eab
.subckt aib_io_rx DOUT PAD VDDIO VSS
Xesd PAD PADI VDDIO VSS aib_pad_esd
Xrx PADI DOUT VDDIO VSS aib_rx_data
.ends
** sch_path: design/aib_pad_esd.sch
.subckt aib_pad_esd PAD PADI VDDIO VSS
*.PININFO PAD:B PADI:B VDDIO:B VSS:B
XDp1 VDDIO PAD VSS diodevdd_2kv m=1
XMn1 PAD VSS VSS VSS sg13_lv_nmos w=20u l=0.13u ng=10 m=1
XMclamp VDDIO VSS VSS VSS sg13_lv_nmos w=40u l=0.35u ng=20 m=1
XResd PAD PADI VSS rppd w=2u l=1u m=1 b=0
XDp2 PADI VDDIO dpantenna l=2u w=2u
XMn2 PADI VSS VSS VSS sg13_lv_nmos w=1u l=0.13u ng=1 m=1
.ends
** sch_path: design/aib_rx_data.sch
.subckt aib_rx_data PAD DOUT VDDIO VSS
*.PININFO PAD:I DOUT:O VDDIO:B VSS:B
XMi1p M1 PAD VDDIO VDDIO sg13_lv_pmos w=2.5u l=0.13u ng=2 m=1
XMi1n M1 PAD VSS VSS sg13_lv_nmos w=1u l=0.13u ng=2 m=1
XMi2p DOUT M1 VDDIO VDDIO sg13_lv_pmos w=4u l=0.13u ng=2 m=1
XMi2n DOUT M1 VSS VSS sg13_lv_nmos w=2u l=0.13u ng=2 m=1
.ends
