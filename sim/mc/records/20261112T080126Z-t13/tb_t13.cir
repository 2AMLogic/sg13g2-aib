* tb_t13.cir -- T-13 data-to-data skew at the TX output, single edge pair (A rises, B falls)
* One edge at 2 ns (normalised 0..1 stimulus scaled by the TX supply, 100 ps ramp as the PRBS bench).
* Subject: two aib_tx_data drivers, each through aib_pad_esd, measured at the pad node (near-side
* output, no channel, no receiver); cells .include'd from design/. One supply per block, lockstep.
.include ../../design/aib_tx_data.spice
.include ../../design/aib_pad_esd.spice
Vdd_atx vdd_atx 0 DC 1.2
Vdd_btx vdd_btx 0 DC 1.2
Vpa pa 0 dc 0 pwl(0 0 2n 0 2.1n 1 6n 1)
Vpb pb 0 dc 1 pwl(0 1 2n 1 2.1n 0 6n 0)
Bda da 0 V = v(pa)*v(vdd_atx)
Bdb db 0 V = v(pb)*v(vdd_btx)
* OE high (driving), weak pull-up gate PUN high (off), pull-down gate PD low (off).
Xa da vdd_atx vdd_atx 0 txia vdd_atx 0 aib_tx_data
Xesda pada txia vdd_atx 0 aib_pad_esd
Xb db vdd_btx vdd_btx 0 txib vdd_btx 0 aib_tx_data
Xesdb padb txib vdd_btx 0 aib_pad_esd
Bdsa dsa 0 V = v(pada) - 0.5*v(vdd_atx)
Bdsb dsb 0 V = v(padb) - 0.5*v(vdd_btx)
