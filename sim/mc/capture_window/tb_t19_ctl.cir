* tb_t19_ctl.cir -- T-19 receiver capture window: aib_rx_data input stage -> sg13g2_dfrbpq_1 (generated by gen_t19.py)
* Swept-offset single transient: setup phase then hold phase; see gen_t19.py for the method.
* Supply: one source `vdd_rx` (VDDIO = flop VDD), swept by corners.supply_v.
.include ../../../design/aib_rx_data.spice
.include sg13g2_dfrbpq_1.inc
Vdd_rx vdd_rx 0 DC 1.2
Vpn pn 0 dc 0 pwl(0.0000n 0 0.5500n 0 0.6500n 1 1.5500n 1 1.6500n 0 2.5600n 0 2.6600n 1 3.5500n 1 3.6500n 0 4.5700n 0 4.6700n 1 5.5500n 1 5.6500n 0 6.5800n 0 6.6800n 1 7.5500n 1 7.6500n 0 8.5900n 0 8.6900n 1 9.5500n 1 9.6500n 0 10.6000n 0 10.7000n 1 11.5500n 1 11.6500n 0 12.6100n 0 12.7100n 1 13.5500n 1 13.6500n 0 14.6200n 0 14.7200n 1 15.5500n 1 15.6500n 0 16.6300n 0 16.7300n 1 17.5500n 1 17.6500n 0 18.6400n 0 18.7400n 1 19.5500n 1 19.6500n 0 20.6500n 0 20.7500n 1 21.5500n 1 21.6500n 0 22.6600n 0 22.7600n 1 23.5500n 1 23.6500n 0 24.6700n 0 24.7700n 1 25.5500n 1 25.6500n 0 26.6800n 0 26.7800n 1 27.5500n 1 27.6500n 0 28.6900n 0 28.7900n 1 29.5500n 1 29.6500n 0 30.7000n 0 30.8000n 1 31.5500n 1 31.6500n 0 32.7100n 0 32.8100n 1 33.5500n 1 33.6500n 0 34.7200n 0 34.8200n 1 35.5500n 1 35.6500n 0 36.7300n 0 36.8300n 1 37.5500n 1 37.6500n 0 38.7400n 0 38.8400n 1 39.5500n 1 39.6500n 0 40.7500n 0 40.8500n 1 41.5500n 1 41.6500n 0 42.7600n 0 42.8600n 1 43.5500n 1 43.6500n 0 44.7700n 0 44.8700n 1 45.5500n 1 45.6500n 0 46.7800n 0 46.8800n 1 47.5500n 1 47.6500n 0 48.7900n 0 48.8900n 1 49.5500n 1 49.6500n 0 50.8000n 0 50.9000n 1 51.5500n 1 51.6500n 0 52.8100n 0 52.9100n 1 53.5500n 1 53.6500n 0 54.8200n 0 54.9200n 1 55.5500n 1 55.6500n 0 56.8300n 0 56.9300n 1 57.5500n 1 57.6500n 0 58.8400n 0 58.9400n 1 59.5500n 1 59.6500n 0 60.8500n 0 60.9500n 1 61.5500n 1 61.6500n 0 62.8600n 0 62.9600n 1 63.5500n 1 63.6500n 0 64.8700n 0 64.9700n 1 65.5500n 1 65.6500n 0 66.8800n 0 66.9800n 1 67.5500n 1 67.6500n 0 68.8900n 0 68.9900n 1 69.5500n 1 69.6500n 0 70.9000n 0 71.0000n 1 71.5500n 1 71.6500n 0 72.9100n 0 73.0100n 1 73.5500n 1 73.6500n 0 74.9200n 0 75.0200n 1 75.5500n 1 75.6500n 0 76.9300n 0 77.0300n 1 77.5500n 1 77.6500n 0 78.9400n 0 79.0400n 1 79.5500n 1 79.6500n 0 80.9500n 0 81.0500n 1 81.5500n 1 81.6500n 0 82.9600n 0 83.0600n 1 83.5500n 1 83.6500n 0 84.9700n 0 85.0700n 1 85.5500n 1 85.6500n 0 86.9800n 0 87.0800n 1 87.5500n 1 87.6500n 0 88.9900n 0 89.0900n 1 89.5500n 1 89.6500n 0 91.0000n 0 91.1000n 1 91.5500n 1 91.6500n 0 93.0100n 0 93.1100n 1 93.5500n 1 93.6500n 0 95.0200n 0 95.1200n 1 95.5500n 1 95.6500n 0 97.0300n 0 97.1300n 1 97.5500n 1 97.6500n 0 99.0400n 0 99.1400n 1 99.5500n 1 99.6500n 0 101.0500n 0 101.1500n 1 101.5500n 1 101.6500n 0 102.2500n 0 102.3500n 1 102.5500n 1 102.6500n 0 104.2500n 0 104.3500n 1 104.5600n 1 104.6600n 0 106.2500n 0 106.3500n 1 106.5700n 1 106.6700n 0 108.2500n 0 108.3500n 1 108.5800n 1 108.6800n 0 110.2500n 0 110.3500n 1 110.5900n 1 110.6900n 0 112.2500n 0 112.3500n 1 112.6000n 1 112.7000n 0 114.2500n 0 114.3500n 1 114.6100n 1 114.7100n 0 116.2500n 0 116.3500n 1 116.6200n 1 116.7200n 0 118.2500n 0 118.3500n 1 118.6300n 1 118.7300n 0 120.2500n 0 120.3500n 1 120.6400n 1 120.7400n 0 122.2500n 0 122.3500n 1 122.6500n 1 122.7500n 0 124.2500n 0 124.3500n 1 124.6600n 1 124.7600n 0 126.2500n 0 126.3500n 1 126.6700n 1 126.7700n 0 128.2500n 0 128.3500n 1 128.6800n 1 128.7800n 0 130.2500n 0 130.3500n 1 130.6900n 1 130.7900n 0 132.2500n 0 132.3500n 1 132.7000n 1 132.8000n 0 134.2500n 0 134.3500n 1 134.7100n 1 134.8100n 0 136.2500n 0 136.3500n 1 136.7200n 1 136.8200n 0 138.2500n 0 138.3500n 1 138.7300n 1 138.8300n 0 140.2500n 0 140.3500n 1 140.7400n 1 140.8400n 0 142.2500n 0 142.3500n 1 142.7500n 1 142.8500n 0 144.2500n 0 144.3500n 1 144.7600n 1 144.8600n 0 146.2500n 0 146.3500n 1 146.7700n 1 146.8700n 0 148.2500n 0 148.3500n 1 148.7800n 1 148.8800n 0 150.2500n 0 150.3500n 1 150.7900n 1 150.8900n 0 152.2500n 0 152.3500n 1 152.8000n 1 152.9000n 0 154.2500n 0 154.3500n 1 154.8100n 1 154.9100n 0 156.2500n 0 156.3500n 1 156.8200n 1 156.9200n 0 158.2500n 0 158.3500n 1 158.8300n 1 158.9300n 0 160.2500n 0 160.3500n 1 160.8400n 1 160.9400n 0 162.2500n 0 162.3500n 1 162.8500n 1 162.9500n 0 164.2500n 0 164.3500n 1 164.8600n 1 164.9600n 0 166.2500n 0 166.3500n 1 166.8700n 1 166.9700n 0 168.2500n 0 168.3500n 1 168.8800n 1 168.9800n 0 170.2500n 0 170.3500n 1 170.8900n 1 170.9900n 0 172.2500n 0 172.3500n 1 172.9000n 1 173.0000n 0 174.2500n 0 174.3500n 1 174.9100n 1 175.0100n 0 176.2500n 0 176.3500n 1 176.9200n 1 177.0200n 0 178.2500n 0 178.3500n 1 178.9300n 1 179.0300n 0 180.2500n 0 180.3500n 1 180.9400n 1 181.0400n 0 182.2500n 0 182.3500n 1 182.9500n 1 183.0500n 0 184.2500n 0 184.3500n 1 184.9600n 1 185.0600n 0 186.2500n 0 186.3500n 1 186.9700n 1 187.0700n 0 188.2500n 0 188.3500n 1 188.9800n 1 189.0800n 0 190.2500n 0 190.3500n 1 190.9900n 1 191.0900n 0 192.2500n 0 192.3500n 1 193.0000n 1 193.1000n 0 194.2500n 0 194.3500n 1 195.0100n 1 195.1100n 0 196.2500n 0 196.3500n 1 197.0200n 1 197.1200n 0 198.2500n 0 198.3500n 1 199.0300n 1 199.1300n 0 200.2500n 0 200.3500n 1 201.0400n 1 201.1400n 0 202.2500n 0 202.3500n 1 203.0500n 1 203.1500n 0)
Vcn cn 0 dc 0 pwl(0.0000n 0 0.2500n 0 1.7500n 1 1.8500n 1 1.9500n 0 2.2500n 0 3.7500n 1 3.8500n 1 3.9500n 0 4.2500n 0 5.7500n 1 5.8500n 1 5.9500n 0 6.2500n 0 7.7500n 1 7.8500n 1 7.9500n 0 8.2500n 0 9.7500n 1 9.8500n 1 9.9500n 0 10.2500n 0 11.7500n 1 11.8500n 1 11.9500n 0 12.2500n 0 13.7500n 1 13.8500n 1 13.9500n 0 14.2500n 0 15.7500n 1 15.8500n 1 15.9500n 0 16.2500n 0 17.7500n 1 17.8500n 1 17.9500n 0 18.2500n 0 19.7500n 1 19.8500n 1 19.9500n 0 20.2500n 0 21.7500n 1 21.8500n 1 21.9500n 0 22.2500n 0 23.7500n 1 23.8500n 1 23.9500n 0 24.2500n 0 25.7500n 1 25.8500n 1 25.9500n 0 26.2500n 0 27.7500n 1 27.8500n 1 27.9500n 0 28.2500n 0 29.7500n 1 29.8500n 1 29.9500n 0 30.2500n 0 31.7500n 1 31.8500n 1 31.9500n 0 32.2500n 0 33.7500n 1 33.8500n 1 33.9500n 0 34.2500n 0 35.7500n 1 35.8500n 1 35.9500n 0 36.2500n 0 37.7500n 1 37.8500n 1 37.9500n 0 38.2500n 0 39.7500n 1 39.8500n 1 39.9500n 0 40.2500n 0 41.7500n 1 41.8500n 1 41.9500n 0 42.2500n 0 43.7500n 1 43.8500n 1 43.9500n 0 44.2500n 0 45.7500n 1 45.8500n 1 45.9500n 0 46.2500n 0 47.7500n 1 47.8500n 1 47.9500n 0 48.2500n 0 49.7500n 1 49.8500n 1 49.9500n 0 50.2500n 0 51.7500n 1 51.8500n 1 51.9500n 0 52.2500n 0 53.7500n 1 53.8500n 1 53.9500n 0 54.2500n 0 55.7500n 1 55.8500n 1 55.9500n 0 56.2500n 0 57.7500n 1 57.8500n 1 57.9500n 0 58.2500n 0 59.7500n 1 59.8500n 1 59.9500n 0 60.2500n 0 61.7500n 1 61.8500n 1 61.9500n 0 62.2500n 0 63.7500n 1 63.8500n 1 63.9500n 0 64.2500n 0 65.7500n 1 65.8500n 1 65.9500n 0 66.2500n 0 67.7500n 1 67.8500n 1 67.9500n 0 68.2500n 0 69.7500n 1 69.8500n 1 69.9500n 0 70.2500n 0 71.7500n 1 71.8500n 1 71.9500n 0 72.2500n 0 73.7500n 1 73.8500n 1 73.9500n 0 74.2500n 0 75.7500n 1 75.8500n 1 75.9500n 0 76.2500n 0 77.7500n 1 77.8500n 1 77.9500n 0 78.2500n 0 79.7500n 1 79.8500n 1 79.9500n 0 80.2500n 0 81.7500n 1 81.8500n 1 81.9500n 0 82.2500n 0 83.7500n 1 83.8500n 1 83.9500n 0 84.2500n 0 85.7500n 1 85.8500n 1 85.9500n 0 86.2500n 0 87.7500n 1 87.8500n 1 87.9500n 0 88.2500n 0 89.7500n 1 89.8500n 1 89.9500n 0 90.2500n 0 91.7500n 1 91.8500n 1 91.9500n 0 92.2500n 0 93.7500n 1 93.8500n 1 93.9500n 0 94.2500n 0 95.7500n 1 95.8500n 1 95.9500n 0 96.2500n 0 97.7500n 1 97.8500n 1 97.9500n 0 98.2500n 0 99.7500n 1 99.8500n 1 99.9500n 0 100.2500n 0 101.7500n 1 101.8500n 1 101.9500n 0 102.2500n 0 103.7500n 1 103.8500n 1 103.9500n 0 104.2500n 0 105.7500n 1 105.8500n 1 105.9500n 0 106.2500n 0 107.7500n 1 107.8500n 1 107.9500n 0 108.2500n 0 109.7500n 1 109.8500n 1 109.9500n 0 110.2500n 0 111.7500n 1 111.8500n 1 111.9500n 0 112.2500n 0 113.7500n 1 113.8500n 1 113.9500n 0 114.2500n 0 115.7500n 1 115.8500n 1 115.9500n 0 116.2500n 0 117.7500n 1 117.8500n 1 117.9500n 0 118.2500n 0 119.7500n 1 119.8500n 1 119.9500n 0 120.2500n 0 121.7500n 1 121.8500n 1 121.9500n 0 122.2500n 0 123.7500n 1 123.8500n 1 123.9500n 0 124.2500n 0 125.7500n 1 125.8500n 1 125.9500n 0 126.2500n 0 127.7500n 1 127.8500n 1 127.9500n 0 128.2500n 0 129.7500n 1 129.8500n 1 129.9500n 0 130.2500n 0 131.7500n 1 131.8500n 1 131.9500n 0 132.2500n 0 133.7500n 1 133.8500n 1 133.9500n 0 134.2500n 0 135.7500n 1 135.8500n 1 135.9500n 0 136.2500n 0 137.7500n 1 137.8500n 1 137.9500n 0 138.2500n 0 139.7500n 1 139.8500n 1 139.9500n 0 140.2500n 0 141.7500n 1 141.8500n 1 141.9500n 0 142.2500n 0 143.7500n 1 143.8500n 1 143.9500n 0 144.2500n 0 145.7500n 1 145.8500n 1 145.9500n 0 146.2500n 0 147.7500n 1 147.8500n 1 147.9500n 0 148.2500n 0 149.7500n 1 149.8500n 1 149.9500n 0 150.2500n 0 151.7500n 1 151.8500n 1 151.9500n 0 152.2500n 0 153.7500n 1 153.8500n 1 153.9500n 0 154.2500n 0 155.7500n 1 155.8500n 1 155.9500n 0 156.2500n 0 157.7500n 1 157.8500n 1 157.9500n 0 158.2500n 0 159.7500n 1 159.8500n 1 159.9500n 0 160.2500n 0 161.7500n 1 161.8500n 1 161.9500n 0 162.2500n 0 163.7500n 1 163.8500n 1 163.9500n 0 164.2500n 0 165.7500n 1 165.8500n 1 165.9500n 0 166.2500n 0 167.7500n 1 167.8500n 1 167.9500n 0 168.2500n 0 169.7500n 1 169.8500n 1 169.9500n 0 170.2500n 0 171.7500n 1 171.8500n 1 171.9500n 0 172.2500n 0 173.7500n 1 173.8500n 1 173.9500n 0 174.2500n 0 175.7500n 1 175.8500n 1 175.9500n 0 176.2500n 0 177.7500n 1 177.8500n 1 177.9500n 0 178.2500n 0 179.7500n 1 179.8500n 1 179.9500n 0 180.2500n 0 181.7500n 1 181.8500n 1 181.9500n 0 182.2500n 0 183.7500n 1 183.8500n 1 183.9500n 0 184.2500n 0 185.7500n 1 185.8500n 1 185.9500n 0 186.2500n 0 187.7500n 1 187.8500n 1 187.9500n 0 188.2500n 0 189.7500n 1 189.8500n 1 189.9500n 0 190.2500n 0 191.7500n 1 191.8500n 1 191.9500n 0 192.2500n 0 193.7500n 1 193.8500n 1 193.9500n 0 194.2500n 0 195.7500n 1 195.8500n 1 195.9500n 0 196.2500n 0 197.7500n 1 197.8500n 1 197.9500n 0 198.2500n 0 199.7500n 1 199.8500n 1 199.9500n 0 200.2500n 0 201.7500n 1 201.8500n 1 201.9500n 0 202.2500n 0 203.7500n 1 203.8500n 1 203.9500n 0)
Vxr xr 0 dc 0 pwl(0.0000n -0.4 0.0010n -0.4 2.0000n -0.4 2.0010n -0.39 4.0000n -0.39 4.0010n -0.38 6.0000n -0.38 6.0010n -0.37 8.0000n -0.37 8.0010n -0.36 10.0000n -0.36 10.0010n -0.35 12.0000n -0.35 12.0010n -0.34 14.0000n -0.34 14.0010n -0.33 16.0000n -0.33 16.0010n -0.32 18.0000n -0.32 18.0010n -0.31 20.0000n -0.31 20.0010n -0.3 22.0000n -0.3 22.0010n -0.29 24.0000n -0.29 24.0010n -0.28 26.0000n -0.28 26.0010n -0.27 28.0000n -0.27 28.0010n -0.26 30.0000n -0.26 30.0010n -0.25 32.0000n -0.25 32.0010n -0.24 34.0000n -0.24 34.0010n -0.23 36.0000n -0.23 36.0010n -0.22 38.0000n -0.22 38.0010n -0.21 40.0000n -0.21 40.0010n -0.2 42.0000n -0.2 42.0010n -0.19 44.0000n -0.19 44.0010n -0.18 46.0000n -0.18 46.0010n -0.17 48.0000n -0.17 48.0010n -0.16 50.0000n -0.16 50.0010n -0.15 52.0000n -0.15 52.0010n -0.14 54.0000n -0.14 54.0010n -0.13 56.0000n -0.13 56.0010n -0.12 58.0000n -0.12 58.0010n -0.11 60.0000n -0.11 60.0010n -0.1 62.0000n -0.1 62.0010n -0.09 64.0000n -0.09 64.0010n -0.08 66.0000n -0.08 66.0010n -0.07 68.0000n -0.07 68.0010n -0.06 70.0000n -0.06 70.0010n -0.05 72.0000n -0.05 72.0010n -0.04 74.0000n -0.04 74.0010n -0.03 76.0000n -0.03 76.0010n -0.02 78.0000n -0.02 78.0010n -0.01 80.0000n -0.01 80.0010n 0 82.0000n 0 82.0010n 0.01 84.0000n 0.01 84.0010n 0.02 86.0000n 0.02 86.0010n 0.03 88.0000n 0.03 88.0010n 0.04 90.0000n 0.04 90.0010n 0.05 92.0000n 0.05 92.0010n 0.06 94.0000n 0.06 94.0010n 0.07 96.0000n 0.07 96.0010n 0.08 98.0000n 0.08 98.0010n 0.09 100.0000n 0.09 100.0010n 0.1)
Vyr yr 0 dc 0 pwl(0.0000n -0.4 102.0000n -0.4 102.0010n -0.4 104.0000n -0.4 104.0010n -0.39 106.0000n -0.39 106.0010n -0.38 108.0000n -0.38 108.0010n -0.37 110.0000n -0.37 110.0010n -0.36 112.0000n -0.36 112.0010n -0.35 114.0000n -0.35 114.0010n -0.34 116.0000n -0.34 116.0010n -0.33 118.0000n -0.33 118.0010n -0.32 120.0000n -0.32 120.0010n -0.31 122.0000n -0.31 122.0010n -0.3 124.0000n -0.3 124.0010n -0.29 126.0000n -0.29 126.0010n -0.28 128.0000n -0.28 128.0010n -0.27 130.0000n -0.27 130.0010n -0.26 132.0000n -0.26 132.0010n -0.25 134.0000n -0.25 134.0010n -0.24 136.0000n -0.24 136.0010n -0.23 138.0000n -0.23 138.0010n -0.22 140.0000n -0.22 140.0010n -0.21 142.0000n -0.21 142.0010n -0.2 144.0000n -0.2 144.0010n -0.19 146.0000n -0.19 146.0010n -0.18 148.0000n -0.18 148.0010n -0.17 150.0000n -0.17 150.0010n -0.16 152.0000n -0.16 152.0010n -0.15 154.0000n -0.15 154.0010n -0.14 156.0000n -0.14 156.0010n -0.13 158.0000n -0.13 158.0010n -0.12 160.0000n -0.12 160.0010n -0.11 162.0000n -0.11 162.0010n -0.1 164.0000n -0.1 164.0010n -0.09 166.0000n -0.09 166.0010n -0.08 168.0000n -0.08 168.0010n -0.07 170.0000n -0.07 170.0010n -0.06 172.0000n -0.06 172.0010n -0.05 174.0000n -0.05 174.0010n -0.04 176.0000n -0.04 176.0010n -0.03 178.0000n -0.03 178.0010n -0.02 180.0000n -0.02 180.0010n -0.01 182.0000n -0.01 182.0010n 0 184.0000n 0 184.0010n 0.01 186.0000n 0.01 186.0010n 0.02 188.0000n 0.02 188.0010n 0.03 190.0000n 0.03 190.0010n 0.04 192.0000n 0.04 192.0010n 0.05 194.0000n 0.05 194.0010n 0.06 196.0000n 0.06 196.0010n 0.07 198.0000n 0.07 198.0010n 0.08 200.0000n 0.08 200.0010n 0.09 202.0000n 0.09 202.0010n 0.1)
Bpad pad 0 V = v(pn)*v(vdd_rx)
Bclk clk 0 V = v(cn)*v(vdd_rx)
Xrx pad d vdd_rx 0 aib_rx_data
Xff q clk d vff vff 0 sg13g2_dfrbpq_1
Cq q 0 5f
* Negative control (not design evidence): the clock edge at the flop ramps over 1500 ps
* instead of 100 ps, which widens the capture aperture; everything else is unchanged.
Vff vff vdd_rx DC 0
* mid-rail-referenced copies so every WHEN/TRIG uses VAL=0 at any supply
Bph padh 0 V = v(pad) - 0.5*v(vdd_rx)
Bdh dh 0 V = v(d) - 0.5*v(vdd_rx)
Bqh qh 0 V = v(q) - 0.5*v(vff)
.end
