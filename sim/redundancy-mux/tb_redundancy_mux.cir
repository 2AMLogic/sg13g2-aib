* tb_redundancy_mux.cir -- T-05 SIM leg: what the shift-redundancy remap mux adds to one TX lane.
* Rows: T-05 (mux added load and delay). Reported, never graded: spec/target-spec.md T-05 states
* no bound of its own for this leg, and none is invented here (spec/decisions/0023-*.md).
*
* Six lanes, one deck, one stimulus, one corner per run -- so every delta below is a difference
* measured inside the same simulation rather than between two runs:
*
*   b   baseline   serializer mux -> aib_tx_data DIN directly (what design/ has today)
*   c   control    a second, identical copy of lane b. c - b is the bench's own noise floor:
*                  the remap stage shorted out, which must reproduce the baseline.
*   m0  with mux   serializer mux -> remap mux selected to A0 -> DIN  (an unrepaired wire)
*   m1  with mux   serializer mux -> remap mux selected to A1 -> DIN  (a shifted wire)
*   m2  sized      as m0, with sg13g2_mux2_2 (drive 2) as the remap stage
*   m3  buffered   as m0, with sg13g2_mux2_1 -> sg13g2_buf_4 as the remap stage
*
* Lanes m2 and m3 are the sized-stage re-measurement of spec/decisions/0024-*.md (#232): the
* first record under DR-0023 measured the drive-1 stand-in at up to 0.184 UI of common added
* delay, and the question those two lanes answer is how much of that is the cell's drive
* strength rather than the placement. They are selected to A0 only -- the select-dependent
* term is a property of the select stack, which sizing does not change, and the first record
* measured it at 0.289 ps worst case over the grid.
*
* Placement (DR-0023): the remap sits on the serialized wire, between the serializer mux and the
* TX cell's DIN, which is what the ratified row's "inside T-12/T-13" presumes. sg13g2_mux2_1 is
* the stand-in for both the serializer mux and the remap stage: synthesis already maps the
* serializer's clock-selected mux to that cell (22 instances in the committed netlist).
*
* Fan-out (rtl/shift_redundancy.v): physical wire j is driven by bit j (A0) or bit j-2 (A1), so
* each serializer output drives TWO remap inputs -- its own wire's A0 and wire j+2's A1 -- instead
* of one DIN. Both with-mux lanes carry that fan-out: the measured mux plus one load-only mux
* (Xrl_*) whose output goes nowhere and which exists only to present the second input load.
* The other input of each remap mux is driven by a neighbour serializer (Xnbr_*) carrying the
* complementary pattern, so the unselected input toggles on every edge (worst-case coupling into
* the select stack) with a realistic standard-cell slew rather than an ideal source.
*
* Supply: ONE source, vdd_tx, swept by corners.supply_v. The standard cells run from the same
* VDDIO the TX cell does; this repo declares no separate core supply, and sim/mc/capture_window
* supplies its vendored flop the same way. DR-0023 records the choice.
*
* Claim scope: CH -- the pad drives aib_pad_esd into the declared channel CH-3MM-RC, so the TX
* output sees its declared load. The lane-internal deltas this record reports are properties of
* the lane, not of the channel; the channel is here to load the pad realistically and is
* identical in all six lanes.
.include ../../spec/channel/channel_rc.cir
.include ../../design/aib_tx_data.spice
.include ../../design/aib_pad_esd.spice
.include sg13g2_mux2_1.inc
.include sg13g2_mux2_2.inc
.include sg13g2_buf_4.inc
.include redundancy_mux_stim.inc

.subckt link txp rxp gnd
Xch txp rxp gnd chan_rlc len_mm=3
.ends

Vdd_tx vdd_tx 0 DC 1.2

* ideal full-rail levels scaled by the supply; OE and PUN high (driving, weak pull-up off), PD low
Bclk clk 0 V = v(pclk)*v(vdd_tx)
Bhi  hi  0 V = v(vdd_tx)
Boe  oe  0 V = v(vdd_tx)

* ---- lane b: baseline -----------------------------------------------------------------
* serializer `wire_o = clk ? o_n : o_p` with o_p = 1, o_n = 0: X = ~clk, a 1010 DDR pattern at 1 Gb/s
Xser_b bs_x hi 0 clk vdd_tx 0 sg13g2_mux2_1
Vpb    bs_x bs 0
Xtx_b  bs oe oe 0 b_pad vdd_tx 0 aib_tx_data
Xesd_b b_ch b_pad vdd_tx 0 aib_pad_esd
Xlk_b  b_ch b_far 0 link

* ---- lane c: control, the same lane built a second time -------------------------------
Xser_c cs_x hi 0 clk vdd_tx 0 sg13g2_mux2_1
Vpc    cs_x cs 0
Xtx_c  cs oe oe 0 c_pad vdd_tx 0 aib_tx_data
Xesd_c c_ch c_pad vdd_tx 0 aib_pad_esd
Xlk_c  c_ch c_far 0 link

* ---- lane m0: remap in the path, measured through A0 (wire j carrying its own bit) -----
Xser_m0 m0s_x hi 0 clk vdd_tx 0 sg13g2_mux2_1
Vpm0    m0s_x m0s 0
Xnbr_m0 n0 0 hi clk vdd_tx 0 sg13g2_mux2_1
Xrm_m0  m0d m0s n0 0 vdd_tx 0 sg13g2_mux2_1
Xrl_m0  l0 n0 m0s 0 vdd_tx 0 sg13g2_mux2_1
Xtx_m0  m0d oe oe 0 m0_pad vdd_tx 0 aib_tx_data
Xesd_m0 m0_ch m0_pad vdd_tx 0 aib_pad_esd
Xlk_m0  m0_ch m0_far 0 link

* ---- lane m1: remap in the path, measured through A1 (wire j+2 carrying bit j) ---------
Xser_m1 m1s_x hi 0 clk vdd_tx 0 sg13g2_mux2_1
Vpm1    m1s_x m1s 0
Xnbr_m1 n1 0 hi clk vdd_tx 0 sg13g2_mux2_1
Xrm_m1  m1d n1 m1s vdd_tx vdd_tx 0 sg13g2_mux2_1
Xrl_m1  l1 m1s n1 vdd_tx vdd_tx 0 sg13g2_mux2_1
Xtx_m1  m1d oe oe 0 m1_pad vdd_tx 0 aib_tx_data
Xesd_m1 m1_ch m1_pad vdd_tx 0 aib_pad_esd
Xlk_m1  m1_ch m1_far 0 link

* ---- lane m2: sized remap, sg13g2_mux2_2 (drive 2), measured through A0 -----------------
* Same topology as m0; only the remap cell changes. The load-only twin Xrl_m2 is the sized
* cell too, because wire j+2's remap is the same instance in any implementation that sizes
* the stage -- and mux2_2's A0/A1 input devices are the same size as mux2_1's, so the load
* this lane's serializer sees is the same either way.
Xser_m2 m2s_x hi 0 clk vdd_tx 0 sg13g2_mux2_1
Vpm2    m2s_x m2s 0
Xnbr_m2 n2 0 hi clk vdd_tx 0 sg13g2_mux2_1
Xrm_m2  m2d m2s n2 0 vdd_tx 0 sg13g2_mux2_2
Xrl_m2  l2 n2 m2s 0 vdd_tx 0 sg13g2_mux2_2
Xtx_m2  m2d oe oe 0 m2_pad vdd_tx 0 aib_tx_data
Xesd_m2 m2_ch m2_pad vdd_tx 0 aib_pad_esd
Xlk_m2  m2_ch m2_far 0 link

* ---- lane m3: buffered remap, sg13g2_mux2_1 -> sg13g2_buf_4, measured through A0 --------
* The remap mux keeps the minimum-strength cell -- so the serializer sees exactly the m0
* fan-out -- and the ~30 fF DIN is driven by the buffer instead. The buffer is in the lane,
* not on the load-only twin: Xrl_m3 models the input load wire j+2's remap presents, which
* is the mux input in both arrangements.
Xser_m3 m3s_x hi 0 clk vdd_tx 0 sg13g2_mux2_1
Vpm3    m3s_x m3s 0
Xnbr_m3 n3 0 hi clk vdd_tx 0 sg13g2_mux2_1
Xrm_m3  m3x m3s n3 0 vdd_tx 0 sg13g2_mux2_1
Xbuf_m3 m3d m3x vdd_tx 0 sg13g2_buf_4
Xrl_m3  l3 n3 m3s 0 vdd_tx 0 sg13g2_mux2_1
Xtx_m3  m3d oe oe 0 m3_pad vdd_tx 0 aib_tx_data
Xesd_m3 m3_ch m3_pad vdd_tx 0 aib_pad_esd
Xlk_m3  m3_ch m3_far 0 link

* ---- mid-rail-referenced probes so every TRIG/TARG uses VAL=0 at any supply ------------
Bhclk hclk 0 V = v(clk)    - 0.5*v(vdd_tx)
Bhb   hb   0 V = v(b_pad)  - 0.5*v(vdd_tx)
Bhc   hc   0 V = v(c_pad)  - 0.5*v(vdd_tx)
Bhm0  hm0  0 V = v(m0_pad) - 0.5*v(vdd_tx)
Bhm1  hm1  0 V = v(m1_pad) - 0.5*v(vdd_tx)
Bhm2  hm2  0 V = v(m2_pad) - 0.5*v(vdd_tx)
Bhm3  hm3  0 V = v(m3_pad) - 0.5*v(vdd_tx)
Bhbs  hbs  0 V = v(bs)  - 0.5*v(vdd_tx)
Bhcs  hcs  0 V = v(cs)  - 0.5*v(vdd_tx)
Bhm0s hm0s 0 V = v(m0s) - 0.5*v(vdd_tx)
Bhm1s hm1s 0 V = v(m1s) - 0.5*v(vdd_tx)
Bhm2s hm2s 0 V = v(m2s) - 0.5*v(vdd_tx)
Bhm3s hm3s 0 V = v(m3s) - 0.5*v(vdd_tx)

* ---- 10 % / 90 % referenced copies of the serializer outputs (slew = what the load does)
Bbs10  bs10  0 V = v(bs)  - 0.1*v(vdd_tx)
Bbs90  bs90  0 V = v(bs)  - 0.9*v(vdd_tx)
Bcs10  cs10  0 V = v(cs)  - 0.1*v(vdd_tx)
Bcs90  cs90  0 V = v(cs)  - 0.9*v(vdd_tx)
Bm0s10 m0s10 0 V = v(m0s) - 0.1*v(vdd_tx)
Bm0s90 m0s90 0 V = v(m0s) - 0.9*v(vdd_tx)
Bm1s10 m1s10 0 V = v(m1s) - 0.1*v(vdd_tx)
Bm1s90 m1s90 0 V = v(m1s) - 0.9*v(vdd_tx)
Bm2s10 m2s10 0 V = v(m2s) - 0.1*v(vdd_tx)
Bm2s90 m2s90 0 V = v(m2s) - 0.9*v(vdd_tx)
Bm3s10 m3s10 0 V = v(m3s) - 0.1*v(vdd_tx)
Bm3s90 m3s90 0 V = v(m3s) - 0.9*v(vdd_tx)

* ---- |load current| at each serializer output; integrated over one whole clock period it
* ---- is 2*Ceff*VDD (one rise and one fall), so the window's endpoints need not be settled.
Bqb  qb  0 V = abs(i(Vpb))
Bqc  qc  0 V = abs(i(Vpc))
Bqm0 qm0 0 V = abs(i(Vpm0))
Bqm1 qm1 0 V = abs(i(Vpm1))
Bqm2 qm2 0 V = abs(i(Vpm2))
Bqm3 qm3 0 V = abs(i(Vpm3))
