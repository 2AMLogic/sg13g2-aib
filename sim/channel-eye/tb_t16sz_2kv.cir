* tb_t16sz_2kv.cir -- tb_ch_spread.cir with the parametric pad cell esd_sz_2kv.inc (issue #251 sizing study).
* Identical to tb_ch.cir (TX -> declared channel model -> RX, four lanes, tb_body.inc)
* except that the R and C spread multipliers of spec/channel/channel_rc.cir are lifted to
* top-level .param and passed into the instance. `corners.params` in a klt sim request can
* only target a top-level .param, not a subcircuit-local one, so the sweep needs this form;
* tb_ch.cir itself is left alone because the nominal records cite it.
* kr = kc = 1 here is the nominal channel; request_ch_spread_1g.json sets the four
* +-20 % combinations (0.8/0.8, 0.8/1.2, 1.2/0.8, 1.2/1.2).
* The channel model includes its own far-end load (cfar); not added again here.
.include ../../spec/channel/channel_rc.cir
.include ../../design/aib_tx_data.spice
.include ../../design/aib_rx_data.spice
.include esd_sz_2kv.inc
.param ch_kr=1 ch_kc=1
.subckt link txp rxp gnd
Xch txp rxp gnd chan_rlc len_mm=3 kr={ch_kr} kc={ch_kc}
.ends link
.include tb_body.inc
