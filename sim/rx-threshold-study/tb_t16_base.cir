* GENERATED by gen_rx_threshold.py; do not edit.
* sim/channel-eye/tb_ch.cir form (CH-3MM-RC, nominal kr = kc = 1, four lanes of
* tb_body.inc with the RX-pin probes the t15/t16 cards read). Variant: as-drawn receiver (self-check against the committed ch record).
.include ../../spec/channel/channel_rc.cir
.include ../../design/aib_tx_data.spice
.include ../../design/aib_pad_esd.spice
* inverter candidate base: XMi1p w=2.5u ng=2, XMi1n w=1u ng=2, both l=0.13u; restore stage as committed
.subckt aib_rx_data PAD DOUT VDDIO VSS
XMi1p M1 PAD VDDIO VDDIO sg13_lv_pmos w=2.5u l=0.13u ng=2 m=1
XMi1n M1 PAD VSS VSS sg13_lv_nmos w=1u l=0.13u ng=2 m=1
XMi2p DOUT M1 VDDIO VDDIO sg13_lv_pmos w=4u l=0.13u ng=2 m=1
XMi2n DOUT M1 VSS VSS sg13_lv_nmos w=2u l=0.13u ng=2 m=1
.ends
.subckt link txp rxp gnd
Xch txp rxp gnd chan_rlc len_mm=3
.ends
* tb_body.inc -- four-lane channel testbench body (circuit body for `klt sim`).
*
* Lanes (each: aib_tx_data -> aib_pad_esd -> link -> aib_pad_esd -> aib_rx_data):
*   A   data lane, PRBS-7                 pin rxa
*   B   data lane, complement of A        pin rxb   (T-15: opposite-polarity edges launch together)
*   C   forwarded clock, clk              pin rxc   (clk and clkb are the quasi-differential pair, T-04)
*   CB  forwarded clock, clkb             pin rxcb
* The including netlist defines `.subckt link txp rxp gnd` first: the declared channel
* CH-3MM-RC (tb_ch.cir) or the declared L2 wire-bond loopback (tb_tc.cir).
*
* Cells are .include'd by the including netlist, never copied. design/aib_{tx,rx}_clk.spice
* embed copies of aib_tx_data / aib_rx_data, so the clock cells are not included next to the
* data cells: the clock lane is two aib_tx_data / aib_rx_data instances, which is what those
* cells are.
.include prbs7_stim.inc

* One lane. OE tied high (driving), weak pull-up gate PUN high (off), pull-down gate PD low (off).
* DOUT carries a declared 5 fF load (an RTL flop input; no PDK or layout value behind it).
.subckt lane din dout rxp vtx vrx
Xtx   din vtx vtx 0 txi vtx 0 aib_tx_data
Xesdt txp txi vtx 0 aib_pad_esd
Xlnk  txp rxp 0 link
Xesdr rxp rxi vrx 0 aib_pad_esd
Xrx   rxi dout vrx 0 aib_rx_data
Cdout dout 0 5f
.ends lane

* Supplies: one source per block so the energy of each is separable; corners.supply_v sweeps
* them together. Nominal value only here, `klt sim` alters it per corner.
Vdd_atx vdd_atx 0 DC 1.2
Vdd_arx vdd_arx 0 DC 1.2
Vdd_btx vdd_btx 0 DC 1.2
Vdd_brx vdd_brx 0 DC 1.2
Vdd_ctx vdd_ctx 0 DC 1.2
Vdd_crx vdd_crx 0 DC 1.2

* Ideal full-rail drivers scaled by the TX supply (stimulus; their current is not counted).
Bda  da  0 V = v(pa)*v(vdd_atx)
Bdb  db  0 V = v(pb)*v(vdd_btx)
Bdcp dcp 0 V = v(pc)*v(vdd_ctx)
Bdcn dcn 0 V = v(pcb)*v(vdd_ctx)

Xa  da  douta  rxa  vdd_atx vdd_arx lane
Xb  db  doutb  rxb  vdd_btx vdd_brx lane
Xcp dcp doutcp rxc  vdd_ctx vdd_crx lane
Xcn dcn doutcn rxcb vdd_ctx vdd_crx lane

* Zero-crossing probes (no loading): data minus RX mid-rail, clock quasi-differential.
Bdsa dsa  0 V = v(rxa) - 0.5*v(vdd_arx)
Bdsb dsb  0 V = v(rxb) - 0.5*v(vdd_brx)
Bcs  csig 0 V = v(rxc) - v(rxcb)
