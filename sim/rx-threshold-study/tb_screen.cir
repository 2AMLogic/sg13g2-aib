* tb_screen.cir -- GENERATED by gen_rx_threshold.py; do not edit.
* T-10 bench form (sim/mc/tb_t10.cir) with every candidate cell instantiated
* on the same pad ramp: one crossing per candidate per corner, directly
* comparable. Cells are inlined from cand_cells.inc, never .include'd, so the
* record copy is self-contained. Candidates are study cells, not design evidence.
Vddio vddio 0 dc 1.2
Vfr fr 0 dc 0.5
Bpin pad 0 V=v(fr)*v(vddio)
* inverter candidate base: XMi1p w=2.5u ng=2, XMi1n w=1u ng=2, both l=0.13u; restore stage as committed
.subckt rx__base PAD DOUT VDDIO VSS
XMi1p M1 PAD VDDIO VDDIO sg13_lv_pmos w=2.5u l=0.13u ng=2 m=1
XMi1n M1 PAD VSS VSS sg13_lv_nmos w=1u l=0.13u ng=2 m=1
XMi2p DOUT M1 VDDIO VDDIO sg13_lv_pmos w=4u l=0.13u ng=2 m=1
XMi2n DOUT M1 VSS VSS sg13_lv_nmos w=2u l=0.13u ng=2 m=1
.ends
* inverter candidate r20: XMi1p w=2.0u ng=2, XMi1n w=1u ng=2, both l=0.13u; restore stage as committed
.subckt rx__r20 PAD DOUT VDDIO VSS
XMi1p M1 PAD VDDIO VDDIO sg13_lv_pmos w=2.0u l=0.13u ng=2 m=1
XMi1n M1 PAD VSS VSS sg13_lv_nmos w=1u l=0.13u ng=2 m=1
XMi2p DOUT M1 VDDIO VDDIO sg13_lv_pmos w=4u l=0.13u ng=2 m=1
XMi2n DOUT M1 VSS VSS sg13_lv_nmos w=2u l=0.13u ng=2 m=1
.ends
* inverter candidate r225: XMi1p w=2.25u ng=2, XMi1n w=1u ng=2, both l=0.13u; restore stage as committed
.subckt rx__r225 PAD DOUT VDDIO VSS
XMi1p M1 PAD VDDIO VDDIO sg13_lv_pmos w=2.25u l=0.13u ng=2 m=1
XMi1n M1 PAD VSS VSS sg13_lv_nmos w=1u l=0.13u ng=2 m=1
XMi2p DOUT M1 VDDIO VDDIO sg13_lv_pmos w=4u l=0.13u ng=2 m=1
XMi2n DOUT M1 VSS VSS sg13_lv_nmos w=2u l=0.13u ng=2 m=1
.ends
* inverter candidate r30: XMi1p w=3.0u ng=2, XMi1n w=1u ng=2, both l=0.13u; restore stage as committed
.subckt rx__r30 PAD DOUT VDDIO VSS
XMi1p M1 PAD VDDIO VDDIO sg13_lv_pmos w=3.0u l=0.13u ng=2 m=1
XMi1n M1 PAD VSS VSS sg13_lv_nmos w=1u l=0.13u ng=2 m=1
XMi2p DOUT M1 VDDIO VDDIO sg13_lv_pmos w=4u l=0.13u ng=2 m=1
XMi2n DOUT M1 VSS VSS sg13_lv_nmos w=2u l=0.13u ng=2 m=1
.ends
* inverter candidate r35: XMi1p w=3.5u ng=2, XMi1n w=1u ng=2, both l=0.13u; restore stage as committed
.subckt rx__r35 PAD DOUT VDDIO VSS
XMi1p M1 PAD VDDIO VDDIO sg13_lv_pmos w=3.5u l=0.13u ng=2 m=1
XMi1n M1 PAD VSS VSS sg13_lv_nmos w=1u l=0.13u ng=2 m=1
XMi2p DOUT M1 VDDIO VDDIO sg13_lv_pmos w=4u l=0.13u ng=2 m=1
XMi2n DOUT M1 VSS VSS sg13_lv_nmos w=2u l=0.13u ng=2 m=1
.ends
* inverter candidate l25: XMi1p w=2.0u ng=2, XMi1n w=1u ng=2, both l=0.25u; restore stage as committed
.subckt rx__l25 PAD DOUT VDDIO VSS
XMi1p M1 PAD VDDIO VDDIO sg13_lv_pmos w=2.0u l=0.25u ng=2 m=1
XMi1n M1 PAD VSS VSS sg13_lv_nmos w=1u l=0.25u ng=2 m=1
XMi2p DOUT M1 VDDIO VDDIO sg13_lv_pmos w=4u l=0.13u ng=2 m=1
XMi2n DOUT M1 VSS VSS sg13_lv_nmos w=2u l=0.13u ng=2 m=1
.ends
* inverter candidate l50: XMi1p w=2.0u ng=2, XMi1n w=1u ng=2, both l=0.5u; restore stage as committed
.subckt rx__l50 PAD DOUT VDDIO VSS
XMi1p M1 PAD VDDIO VDDIO sg13_lv_pmos w=2.0u l=0.5u ng=2 m=1
XMi1n M1 PAD VSS VSS sg13_lv_nmos w=1u l=0.5u ng=2 m=1
XMi2p DOUT M1 VDDIO VDDIO sg13_lv_pmos w=4u l=0.13u ng=2 m=1
XMi2n DOUT M1 VSS VSS sg13_lv_nmos w=2u l=0.13u ng=2 m=1
.ends
* inverter candidate a2: XMi1p w=2.0u ng=4, XMi1n w=1u ng=4, both l=0.13u; restore stage as committed
.subckt rx__a2 PAD DOUT VDDIO VSS
XMi1p M1 PAD VDDIO VDDIO sg13_lv_pmos w=2.0u l=0.13u ng=4 m=1
XMi1n M1 PAD VSS VSS sg13_lv_nmos w=1u l=0.13u ng=4 m=1
XMi2p DOUT M1 VDDIO VDDIO sg13_lv_pmos w=4u l=0.13u ng=2 m=1
XMi2n DOUT M1 VSS VSS sg13_lv_nmos w=2u l=0.13u ng=2 m=1
.ends
* supply-referenced candidate: NMOS pair + PMOS mirror load against a matched
* rppd VDDIO/2 divider; restore inverter at half the committed width. Study cell,
* not design evidence.
.subckt rx__vref PAD DOUT VDDIO VSS
XRdiv1 VDDIO vrn VSS rppd w=0.5u l=48u m=1 b=0
XRdiv2 vrn VSS VSS rppd w=0.5u l=48u m=1 b=0
XMtail s1 VDDIO VSS VSS sg13_lv_nmos w=2u l=0.5u ng=2 m=1
XMnp d1 PAD s1 VSS sg13_lv_nmos w=1u l=0.5u ng=2 m=1
XMnn d2 vrn s1 VSS sg13_lv_nmos w=1u l=0.5u ng=2 m=1
XMlp d2 d2 VDDIO VDDIO sg13_lv_pmos w=4u l=0.25u ng=4 m=1
XMln d1 d2 VDDIO VDDIO sg13_lv_pmos w=4u l=0.25u ng=4 m=1
XMi2p DOUT d1 VDDIO VDDIO sg13_lv_pmos w=2u l=0.13u ng=1 m=1
XMi2n DOUT d1 VSS VSS sg13_lv_nmos w=1u l=0.13u ng=1 m=1
.ends
Xc_base pad do_base vddio 0 rx__base
Bdn_base dnorm_base 0 V=v(do_base)/v(vddio)
Xc_r20 pad do_r20 vddio 0 rx__r20
Bdn_r20 dnorm_r20 0 V=v(do_r20)/v(vddio)
Xc_r225 pad do_r225 vddio 0 rx__r225
Bdn_r225 dnorm_r225 0 V=v(do_r225)/v(vddio)
Xc_r30 pad do_r30 vddio 0 rx__r30
Bdn_r30 dnorm_r30 0 V=v(do_r30)/v(vddio)
Xc_r35 pad do_r35 vddio 0 rx__r35
Bdn_r35 dnorm_r35 0 V=v(do_r35)/v(vddio)
Xc_l25 pad do_l25 vddio 0 rx__l25
Bdn_l25 dnorm_l25 0 V=v(do_l25)/v(vddio)
Xc_l50 pad do_l50 vddio 0 rx__l50
Bdn_l50 dnorm_l50 0 V=v(do_l50)/v(vddio)
Xc_a2 pad do_a2 vddio 0 rx__a2
Bdn_a2 dnorm_a2 0 V=v(do_a2)/v(vddio)
Xc_vref pad do_vref vddio 0 rx__vref
Bdn_vref dnorm_vref 0 V=v(do_vref)/v(vddio)
