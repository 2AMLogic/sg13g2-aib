* tb_hyst.cir -- GENERATED by gen_rx_threshold.py; do not edit.
* T-11 bench form (sim/dc-static/tb_rx_hyst.cir) with the as-drawn receiver and
* the selected candidate on the same pad ramp: one hysteresis number per variant.
Vddio vddio 0 dc 1.2
Vfr fr 0 dc 0
Bpin pad 0 V=v(fr)*v(vddio)
* inverter candidate base: XMi1p w=2.5u ng=2, XMi1n w=1u ng=2, both l=0.13u; restore stage as committed
.subckt aib_rx_data__base PAD DOUT VDDIO VSS
XMi1p M1 PAD VDDIO VDDIO sg13_lv_pmos w=2.5u l=0.13u ng=2 m=1
XMi1n M1 PAD VSS VSS sg13_lv_nmos w=1u l=0.13u ng=2 m=1
XMi2p DOUT M1 VDDIO VDDIO sg13_lv_pmos w=4u l=0.13u ng=2 m=1
XMi2n DOUT M1 VSS VSS sg13_lv_nmos w=2u l=0.13u ng=2 m=1
.ends
* supply-referenced candidate: NMOS pair + PMOS mirror load against a matched
* rppd VDDIO/2 divider; restore inverter at half the committed width. Study cell,
* not design evidence.
.subckt aib_rx_data__cand PAD DOUT VDDIO VSS
XRdiv1 VDDIO vrn VSS rppd w=0.5u l=48u m=1 b=0
XRdiv2 vrn VSS VSS rppd w=0.5u l=48u m=1 b=0
XMtail s1 VDDIO VSS VSS sg13_lv_nmos w=2u l=0.5u ng=2 m=1
XMnp d1 PAD s1 VSS sg13_lv_nmos w=1u l=0.5u ng=2 m=1
XMnn d2 vrn s1 VSS sg13_lv_nmos w=1u l=0.5u ng=2 m=1
XMlp d2 d2 VDDIO VDDIO sg13_lv_pmos w=4u l=0.25u ng=4 m=1
XMln d1 d2 VDDIO VDDIO sg13_lv_pmos w=4u l=0.25u ng=4 m=1
XMi2p DOUT d1 VDDIO VDDIO sg13_lv_pmos w=2u l=0.13u ng=1 m=1
XMi2n DOUT d1 VSS VSS sg13_lv_nmos w=1u l=0.13u ng=1 m=1
.ends
Xrx_b pad do_b vddio 0 aib_rx_data__base
Xrx_c pad do_c vddio 0 aib_rx_data__cand
Bdn_b dnorm_b 0 V=v(do_b)/v(vddio)
Bdn_c dnorm_c 0 V=v(do_c)/v(vddio)
