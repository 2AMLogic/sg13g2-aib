* tb_mc_ctl.cir -- GENERATED by gen_rx_threshold.py; do not edit.
* T-10 negative control: the selected candidate with its input-side NMOS
* made 4x narrower, the seeded degradation the control exists to detect.
* A bench copy, not design evidence; the design cell is NOT included.
* supply-referenced candidate: NMOS pair + PMOS mirror load against a matched
* rppd VDDIO/2 divider; restore inverter at half the committed width. Study cell,
* not design evidence.
.subckt aib_rx_data PAD DOUT VDDIO VSS
XRdiv1 VDDIO vrn VSS rppd w=0.5u l=48u m=1 b=0
XRdiv2 vrn VSS VSS rppd w=0.5u l=48u m=1 b=0
XMtail s1 VDDIO VSS VSS sg13_lv_nmos w=2u l=0.5u ng=2 m=1
XMnp d1 PAD s1 VSS sg13_lv_nmos w=0.25u l=0.5u ng=1 m=1
XMnn d2 vrn s1 VSS sg13_lv_nmos w=1u l=0.5u ng=2 m=1
XMlp d2 d2 VDDIO VDDIO sg13_lv_pmos w=4u l=0.25u ng=4 m=1
XMln d1 d2 VDDIO VDDIO sg13_lv_pmos w=4u l=0.25u ng=4 m=1
XMi2p DOUT d1 VDDIO VDDIO sg13_lv_pmos w=2u l=0.13u ng=1 m=1
XMi2n DOUT d1 VSS VSS sg13_lv_nmos w=1u l=0.13u ng=1 m=1
.ends
Vddio vddio 0 dc 1.2
Vfr fr 0 dc 0.5
Bpin pad 0 V=v(fr)*v(vddio)
Xrx pad dout vddio 0 aib_rx_data
Bdn dnorm 0 V=v(dout)/v(vddio)
