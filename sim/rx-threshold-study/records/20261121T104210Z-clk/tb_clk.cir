* tb_clk.cir -- GENERATED by gen_rx_threshold.py; do not edit.
* sim/clock-path/tb_clock_path.cir form with the path instantiated three times:
* variant b on the committed receiver, variant c on the selected candidate in
* both clock legs and the data lane, variant d on the adoptable split (the
* candidate in the data lane, the committed receiver in the clock legs). Only
* t02's opposite-edge separations are measured; the ideal stimulus is shared,
* so every path sees identical edges. TX and ESD cells are included from
* design/, as in the committed bench; the receivers are inlined.
.include ../../spec/channel/channel_rc.cir
.include ../../design/aib_tx_clk.spice
.include ../../design/aib_tx_data.spice
.include ../../design/aib_pad_esd.spice
.subckt link txp rxp gnd
Xch txp rxp gnd chan_rlc len_mm=3
.ends
Vpc pc 0 dc 0 pwl(0 0 5e-10 0 6e-10 1 1.5e-09 1 1.6e-09 0 2.5e-09 0 2.6e-09 1 3.5e-09 1 3.6e-09 0 4.5e-09 0 4.6e-09 1 5.5e-09 1 5.6e-09 0 6.5e-09 0 6.6e-09 1 7.5e-09 1 7.6e-09 0 8.5e-09 0 8.6e-09 1 9.5e-09 1 9.6e-09 0 1.05e-08 0 1.06e-08 1 1.15e-08 1 1.16e-08 0 1.25e-08 0 1.26e-08 1 1.35e-08 1 1.36e-08 0 1.45e-08 0 1.46e-08 1 1.55e-08 1 1.56e-08 0 1.65e-08 0 1.66e-08 1 1.75e-08 1 1.76e-08 0 1.85e-08 0 1.86e-08 1 1.95e-08 1 1.96e-08 0 2.05e-08 0 2.06e-08 1 2.15e-08 1 2.16e-08 0 2.25e-08 0 2.26e-08 1 2.35e-08 1 2.36e-08 0 2.4e-08 0)
Vpd pd_ 0 dc 0 pwl(0 0 0 0 1e-10 1 1e-09 1 1.1e-09 0 2e-09 0 2.1e-09 1 3e-09 1 3.1e-09 0 4e-09 0 4.1e-09 1 5e-09 1 5.1e-09 0 6e-09 0 6.1e-09 1 7e-09 1 7.1e-09 0 8e-09 0 8.1e-09 1 9e-09 1 9.1e-09 0 1e-08 0 1.01e-08 1 1.1e-08 1 1.11e-08 0 1.2e-08 0 1.21e-08 1 1.3e-08 1 1.31e-08 0 1.4e-08 0 1.41e-08 1 1.5e-08 1 1.51e-08 0 1.6e-08 0 1.61e-08 1 1.7e-08 1 1.71e-08 0 1.8e-08 0 1.81e-08 1 1.9e-08 1 1.91e-08 0 2e-08 0 2.01e-08 1 2.1e-08 1 2.11e-08 0 2.2e-08 0 2.21e-08 1 2.3e-08 1 2.31e-08 0 2.4e-08 0)
* inverter candidate base: XMi1p w=2.5u ng=2, XMi1n w=1u ng=2, both l=0.13u; restore stage as committed
.subckt aib_rx_data__base PAD DOUT VDDIO VSS
XMi1p M1 PAD VDDIO VDDIO sg13_lv_pmos w=2.5u l=0.13u ng=2 m=1
XMi1n M1 PAD VSS VSS sg13_lv_nmos w=1u l=0.13u ng=2 m=1
XMi2p DOUT M1 VDDIO VDDIO sg13_lv_pmos w=4u l=0.13u ng=2 m=1
XMi2n DOUT M1 VSS VSS sg13_lv_nmos w=2u l=0.13u ng=2 m=1
.ends
* supply-referenced candidate: NMOS pair + PMOS mirror load against a matched
* rppd VDDIO/2 divider; restore inverter at half the committed width. Study cell,
* not design evidence.
.subckt aib_rx_data__cand PAD DOUT VDDIO VSS
XRdiv1 VDDIO vrn VSS rppd w=0.5u l=48u m=1 b=0
XRdiv2 vrn VSS VSS rppd w=0.5u l=48u m=1 b=0
XMtail s1 VDDIO VSS VSS sg13_lv_nmos w=2u l=0.5u ng=2 m=1
XMnp d1 PAD s1 VSS sg13_lv_nmos w=1u l=0.5u ng=2 m=1
XMnn d2 vrn s1 VSS sg13_lv_nmos w=1u l=0.5u ng=2 m=1
XMlp d2 d2 VDDIO VDDIO sg13_lv_pmos w=4u l=0.25u ng=4 m=1
XMln d1 d2 VDDIO VDDIO sg13_lv_pmos w=4u l=0.25u ng=4 m=1
XMi2p DOUT d1 VDDIO VDDIO sg13_lv_pmos w=2u l=0.13u ng=1 m=1
XMi2n DOUT d1 VSS VSS sg13_lv_nmos w=1u l=0.13u ng=1 m=1
.ends
* the committed clock receiver: aib_rx_clk is two aib_rx_data instances
.subckt aib_rx_clk__base CLK_PAD CLKB_PAD CLK_O CLKB_O VDDIO VSS
Xclk CLK_PAD CLK_O VDDIO VSS aib_rx_data__base
Xclkb CLKB_PAD CLKB_O VDDIO VSS aib_rx_data__base
.ends
* the study clock receiver: same cell with the selected candidate in both legs
.subckt aib_rx_clk__cand CLK_PAD CLKB_PAD CLK_O CLKB_O VDDIO VSS
Xclk CLK_PAD CLK_O VDDIO VSS aib_rx_data__cand
Xclkb CLKB_PAD CLKB_O VDDIO VSS aib_rx_data__cand
.ends
Vdd_tx_b vdd_tx_b 0 DC 1.2
Vdd_rx_b vdd_rx_b 0 DC 1.2
Bckp_b ckp_b 0 V=v(pc)*v(vdd_tx_b)
Bckn_b ckn_b 0 V=(1-v(pc))*v(vdd_tx_b)
Bdd_b dd_b 0 V=v(pd_)*v(vdd_tx_b)
Boe_b oe_b 0 V=v(vdd_tx_b)
Xtxc_b ckp_b ckn_b oe_b oe_b 0 txc_b txcb_b vdd_tx_b 0 aib_tx_clk
Xetc_b txpc_b txc_b vdd_tx_b 0 aib_pad_esd
Xetcb_b txpcb_b txcb_b vdd_tx_b 0 aib_pad_esd
Xlc_b txpc_b rxpc_b 0 link
Xlcb_b txpcb_b rxpcb_b 0 link
Xerc_b rxpc_b rxc_b vdd_rx_b 0 aib_pad_esd
Xercb_b rxpcb_b rxcb_b vdd_rx_b 0 aib_pad_esd
Xrxc_b rxc_b rxcb_b cko_b ckbo_b vdd_rx_b 0 aib_rx_clk__base
Xtxd_b dd_b oe_b oe_b 0 txdc_b vdd_tx_b 0 aib_tx_data
Xetd_b txpd_b txdc_b vdd_tx_b 0 aib_pad_esd
Xld_b txpd_b rxpd_b 0 link
Xerd_b rxpd_b rxd_b vdd_rx_b 0 aib_pad_esd
Xrxd_b rxd_b ddo_b vdd_rx_b 0 aib_rx_data__base
Ccko_b cko_b 0 5f
Cckbo_b ckbo_b 0 5f
Cddo_b ddo_b 0 5f
Bdxo_b dxo_b 0 V=v(cko_b)-0.5*v(vdd_rx_b)
Bdd0_b ddo0_b 0 V=v(ddo_b)-0.5*v(vdd_rx_b)
Vdd_tx_c vdd_tx_c 0 DC 1.2
Vdd_rx_c vdd_rx_c 0 DC 1.2
Bckp_c ckp_c 0 V=v(pc)*v(vdd_tx_c)
Bckn_c ckn_c 0 V=(1-v(pc))*v(vdd_tx_c)
Bdd_c dd_c 0 V=v(pd_)*v(vdd_tx_c)
Boe_c oe_c 0 V=v(vdd_tx_c)
Xtxc_c ckp_c ckn_c oe_c oe_c 0 txc_c txcb_c vdd_tx_c 0 aib_tx_clk
Xetc_c txpc_c txc_c vdd_tx_c 0 aib_pad_esd
Xetcb_c txpcb_c txcb_c vdd_tx_c 0 aib_pad_esd
Xlc_c txpc_c rxpc_c 0 link
Xlcb_c txpcb_c rxpcb_c 0 link
Xerc_c rxpc_c rxc_c vdd_rx_c 0 aib_pad_esd
Xercb_c rxpcb_c rxcb_c vdd_rx_c 0 aib_pad_esd
Xrxc_c rxc_c rxcb_c cko_c ckbo_c vdd_rx_c 0 aib_rx_clk__cand
Xtxd_c dd_c oe_c oe_c 0 txdc_c vdd_tx_c 0 aib_tx_data
Xetd_c txpd_c txdc_c vdd_tx_c 0 aib_pad_esd
Xld_c txpd_c rxpd_c 0 link
Xerd_c rxpd_c rxd_c vdd_rx_c 0 aib_pad_esd
Xrxd_c rxd_c ddo_c vdd_rx_c 0 aib_rx_data__cand
Ccko_c cko_c 0 5f
Cckbo_c ckbo_c 0 5f
Cddo_c ddo_c 0 5f
Bdxo_c dxo_c 0 V=v(cko_c)-0.5*v(vdd_rx_c)
Bdd0_c ddo0_c 0 V=v(ddo_c)-0.5*v(vdd_rx_c)
Vdd_tx_d vdd_tx_d 0 DC 1.2
Vdd_rx_d vdd_rx_d 0 DC 1.2
Bckp_d ckp_d 0 V=v(pc)*v(vdd_tx_d)
Bckn_d ckn_d 0 V=(1-v(pc))*v(vdd_tx_d)
Bdd_d dd_d 0 V=v(pd_)*v(vdd_tx_d)
Boe_d oe_d 0 V=v(vdd_tx_d)
Xtxc_d ckp_d ckn_d oe_d oe_d 0 txc_d txcb_d vdd_tx_d 0 aib_tx_clk
Xetc_d txpc_d txc_d vdd_tx_d 0 aib_pad_esd
Xetcb_d txpcb_d txcb_d vdd_tx_d 0 aib_pad_esd
Xlc_d txpc_d rxpc_d 0 link
Xlcb_d txpcb_d rxpcb_d 0 link
Xerc_d rxpc_d rxc_d vdd_rx_d 0 aib_pad_esd
Xercb_d rxpcb_d rxcb_d vdd_rx_d 0 aib_pad_esd
Xrxc_d rxc_d rxcb_d cko_d ckbo_d vdd_rx_d 0 aib_rx_clk__base
Xtxd_d dd_d oe_d oe_d 0 txdc_d vdd_tx_d 0 aib_tx_data
Xetd_d txpd_d txdc_d vdd_tx_d 0 aib_pad_esd
Xld_d txpd_d rxpd_d 0 link
Xerd_d rxpd_d rxd_d vdd_rx_d 0 aib_pad_esd
Xrxd_d rxd_d ddo_d vdd_rx_d 0 aib_rx_data__cand
Ccko_d cko_d 0 5f
Cckbo_d ckbo_d 0 5f
Cddo_d ddo_d 0 5f
Bdxo_d dxo_d 0 V=v(cko_d)-0.5*v(vdd_rx_d)
Bdd0_d ddo0_d 0 V=v(ddo_d)-0.5*v(vdd_rx_d)
