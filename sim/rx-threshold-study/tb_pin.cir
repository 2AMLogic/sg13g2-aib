* tb_pin.cir -- GENERATED by gen_rx_threshold.py; do not edit.
* sim/dc-static/tb_pin.cir form with two pins on shared control levels: variant b
* carries the as-drawn receiver, variant c the selected candidate. Only the receiver
* differs, so the capacitance delta is the candidate's alone. The ESD and TX cells
* are included from design/, as in the committed bench; the receivers are inlined.
Voef oef 0 dc 0
Vdinf dinf 0 dc 0
Vpunf punf 0 dc 1
Vpdf pdf 0 dc 0
Boe oe_p 0 V=v(oef)*v(vddio)
Bdin din_p 0 V=v(dinf)*v(vddio)
Bpun pun_p 0 V=v(punf)*v(vddio)
Bpd pd_p 0 V=v(pdf)*v(vddio)
Vddio vddio 0 dc 1.2
.include ../../design/aib_pad_esd.spice
.include ../../design/aib_tx_data.spice
* inverter candidate base: XMi1p w=2.5u ng=2, XMi1n w=1u ng=2, both l=0.13u; restore stage as committed
.subckt aib_rx_data__base PAD DOUT VDDIO VSS
XMi1p M1 PAD VDDIO VDDIO sg13_lv_pmos w=2.5u l=0.13u ng=2 m=1
XMi1n M1 PAD VSS VSS sg13_lv_nmos w=1u l=0.13u ng=2 m=1
XMi2p DOUT M1 VDDIO VDDIO sg13_lv_pmos w=4u l=0.13u ng=2 m=1
XMi2n DOUT M1 VSS VSS sg13_lv_nmos w=2u l=0.13u ng=2 m=1
.ends
* supply-referenced candidate: NMOS pair + PMOS mirror load against a matched
* rppd VDDIO/2 divider; restore inverter at half the committed width. Study cell,
* not design evidence.
.subckt aib_rx_data__cand PAD DOUT VDDIO VSS
XRdiv1 VDDIO vrn VSS rppd w=0.5u l=48u m=1 b=0
XRdiv2 vrn VSS VSS rppd w=0.5u l=48u m=1 b=0
XMtail s1 VDDIO VSS VSS sg13_lv_nmos w=2u l=0.5u ng=2 m=1
XMnp d1 PAD s1 VSS sg13_lv_nmos w=1u l=0.5u ng=2 m=1
XMnn d2 vrn s1 VSS sg13_lv_nmos w=1u l=0.5u ng=2 m=1
XMlp d2 d2 VDDIO VDDIO sg13_lv_pmos w=4u l=0.25u ng=4 m=1
XMln d1 d2 VDDIO VDDIO sg13_lv_pmos w=4u l=0.25u ng=4 m=1
XMi2p DOUT d1 VDDIO VDDIO sg13_lv_pmos w=2u l=0.13u ng=1 m=1
XMi2n DOUT d1 VSS VSS sg13_lv_nmos w=1u l=0.13u ng=1 m=1
.ends
Vpf_b pf_b 0 dc 0
Bpin_b pb_b 0 V=v(pf_b)*v(vddio)
Vacp_b pad_b pb_b dc 0 ac 0
Xesd_b pad_b padi_b vddio 0 aib_pad_esd
Xtx_b din_p oe_p pun_p pd_p pad_b vddio 0 aib_tx_data
Xrx_b padi_b dout_b vddio 0 aib_rx_data__base
Vpf_c pf_c 0 dc 0
Bpin_c pb_c 0 V=v(pf_c)*v(vddio)
Vacp_c pad_c pb_c dc 0 ac 0
Xesd_c pad_c padi_c vddio 0 aib_pad_esd
Xtx_c din_p oe_p pun_p pd_p pad_c vddio 0 aib_tx_data
Xrx_c padi_c dout_c vddio 0 aib_rx_data__cand
