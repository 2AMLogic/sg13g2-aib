* tb_channel_model.cir -- GENERATED by gen_channel_model.py; do not edit.
* T-12 conformance bench: spec/channel/channel_rc.cir (the DUT, two bare chan_rlc
* instances) against reference ladders built from the declared table values
* (spec/channel-model.md, parsed by the generator), through identical probes. The
* request grades DUT/reference ratios at +-1 %: a property of the check, not a
* spec bound. Differential on purpose: the probe-frequency observables differ from
* the lumped constants by corrections of the declared ladder itself (README
* "Why differential"), which cancel between the two sides.
* ch_len/ch_kr/ch_kc are top-level .param so corners.params can sweep them:
* 3/1/5 mm at (kr, kc) = (1,1) and the four
* declared +-20 % combinations of (0.8, 1.2).
.include ../../spec/channel/channel_rc.cir
.param ch_len=3 ch_kr=1 ch_kc=1
* the declared per-mm values and far-end load, as parsed from spec/channel-model.md
.param tb_r_mm=5.5 tb_c_mm=0.20p tb_l_mm=0.5n tb_cfar=0.1p
* DUT, far end shorted: at DC the caps are open, so v(txa) at 1 A is the series R
Xs txa rxa 0 chan_rlc len_mm={ch_len} kr={ch_kr} kc={ch_kc}
Vsh rxa 0 0
Iza 0 txa dc 1 ac 1
* DUT, far end open (Rleak only gives the DC operating point a path)
Xo txb rxb 0 chan_rlc len_mm={ch_len} kr={ch_kr} kc={ch_kc}
Rleak txb 0 1e12
Izb 0 txb dc 0 ac 1
* reference, far end shorted
Cya0 ya0 0 {ch_kc*tb_c_mm*ch_len/10/2}
Rya1 ya0 qya1 {ch_kr*tb_r_mm*ch_len/10}
Lya1 qya1 ya1 {tb_l_mm*ch_len/10}
Cya1 ya1 0 {ch_kc*tb_c_mm*ch_len/10}
Rya2 ya1 qya2 {ch_kr*tb_r_mm*ch_len/10}
Lya2 qya2 ya2 {tb_l_mm*ch_len/10}
Cya2 ya2 0 {ch_kc*tb_c_mm*ch_len/10}
Rya3 ya2 qya3 {ch_kr*tb_r_mm*ch_len/10}
Lya3 qya3 ya3 {tb_l_mm*ch_len/10}
Cya3 ya3 0 {ch_kc*tb_c_mm*ch_len/10}
Rya4 ya3 qya4 {ch_kr*tb_r_mm*ch_len/10}
Lya4 qya4 ya4 {tb_l_mm*ch_len/10}
Cya4 ya4 0 {ch_kc*tb_c_mm*ch_len/10}
Rya5 ya4 qya5 {ch_kr*tb_r_mm*ch_len/10}
Lya5 qya5 ya5 {tb_l_mm*ch_len/10}
Cya5 ya5 0 {ch_kc*tb_c_mm*ch_len/10}
Rya6 ya5 qya6 {ch_kr*tb_r_mm*ch_len/10}
Lya6 qya6 ya6 {tb_l_mm*ch_len/10}
Cya6 ya6 0 {ch_kc*tb_c_mm*ch_len/10}
Rya7 ya6 qya7 {ch_kr*tb_r_mm*ch_len/10}
Lya7 qya7 ya7 {tb_l_mm*ch_len/10}
Cya7 ya7 0 {ch_kc*tb_c_mm*ch_len/10}
Rya8 ya7 qya8 {ch_kr*tb_r_mm*ch_len/10}
Lya8 qya8 ya8 {tb_l_mm*ch_len/10}
Cya8 ya8 0 {ch_kc*tb_c_mm*ch_len/10}
Rya9 ya8 qya9 {ch_kr*tb_r_mm*ch_len/10}
Lya9 qya9 ya9 {tb_l_mm*ch_len/10}
Cya9 ya9 0 {ch_kc*tb_c_mm*ch_len/10}
Rya10 ya9 qya10 {ch_kr*tb_r_mm*ch_len/10}
Lya10 qya10 ya10 {tb_l_mm*ch_len/10}
Cya10 ya10 0 {ch_kc*tb_c_mm*ch_len/10/2}
Vyash ya10 0 0
Irya 0 ya0 dc 1 ac 1
* reference, far end open
Cyb0 yb0 0 {ch_kc*tb_c_mm*ch_len/10/2}
Ryb1 yb0 qyb1 {ch_kr*tb_r_mm*ch_len/10}
Lyb1 qyb1 yb1 {tb_l_mm*ch_len/10}
Cyb1 yb1 0 {ch_kc*tb_c_mm*ch_len/10}
Ryb2 yb1 qyb2 {ch_kr*tb_r_mm*ch_len/10}
Lyb2 qyb2 yb2 {tb_l_mm*ch_len/10}
Cyb2 yb2 0 {ch_kc*tb_c_mm*ch_len/10}
Ryb3 yb2 qyb3 {ch_kr*tb_r_mm*ch_len/10}
Lyb3 qyb3 yb3 {tb_l_mm*ch_len/10}
Cyb3 yb3 0 {ch_kc*tb_c_mm*ch_len/10}
Ryb4 yb3 qyb4 {ch_kr*tb_r_mm*ch_len/10}
Lyb4 qyb4 yb4 {tb_l_mm*ch_len/10}
Cyb4 yb4 0 {ch_kc*tb_c_mm*ch_len/10}
Ryb5 yb4 qyb5 {ch_kr*tb_r_mm*ch_len/10}
Lyb5 qyb5 yb5 {tb_l_mm*ch_len/10}
Cyb5 yb5 0 {ch_kc*tb_c_mm*ch_len/10}
Ryb6 yb5 qyb6 {ch_kr*tb_r_mm*ch_len/10}
Lyb6 qyb6 yb6 {tb_l_mm*ch_len/10}
Cyb6 yb6 0 {ch_kc*tb_c_mm*ch_len/10}
Ryb7 yb6 qyb7 {ch_kr*tb_r_mm*ch_len/10}
Lyb7 qyb7 yb7 {tb_l_mm*ch_len/10}
Cyb7 yb7 0 {ch_kc*tb_c_mm*ch_len/10}
Ryb8 yb7 qyb8 {ch_kr*tb_r_mm*ch_len/10}
Lyb8 qyb8 yb8 {tb_l_mm*ch_len/10}
Cyb8 yb8 0 {ch_kc*tb_c_mm*ch_len/10}
Ryb9 yb8 qyb9 {ch_kr*tb_r_mm*ch_len/10}
Lyb9 qyb9 yb9 {tb_l_mm*ch_len/10}
Cyb9 yb9 0 {ch_kc*tb_c_mm*ch_len/10}
Ryb10 yb9 qyb10 {ch_kr*tb_r_mm*ch_len/10}
Lyb10 qyb10 yb10 {tb_l_mm*ch_len/10}
Cyb10 yb10 0 {ch_kc*tb_c_mm*ch_len/10/2}
Cybfar yb10 0 {tb_cfar}
Rybleak yb0 0 1e12
Iryb 0 yb0 dc 0 ac 1
* the PVT-FULL supply axis rides this dummy rail: the ladder is linear and
* supply-free, so the source exists only that corners.supply_v has a name to alter
Vpvt vpvt 0 dc 1.2
