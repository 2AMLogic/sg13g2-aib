* tb_channel_model.cir -- GENERATED by gen_channel_model.py; do not edit.
* T-12 conformance bench: spec/channel/channel_rc.cir (the DUT, two bare chan_rlc
* instances) against reference ladders built from the declared table values
* (spec/channel-model.md, parsed by the generator), through identical probes. The
* request grades DUT/reference ratios at +-1 %: a property of the check, not a
* spec bound. Differential on purpose: the probe-frequency observables differ from
* the lumped constants by corrections of the declared ladder itself (README
* "Why differential"), which cancel between the two sides.
* ch_len/ch_kr/ch_kc are top-level .param so corners.params can sweep them:
* 3/1/5 mm at (kr, kc) = (1,1) and the four
* declared +-20 % combinations of (0.8, 1.2).
.include ../../spec/channel/channel_rc.cir
.param ch_len=3 ch_kr=1 ch_kc=1
* the declared per-mm values and far-end load, as parsed from spec/channel-model.md
.param tb_r_mm=5.5 tb_c_mm=0.20p tb_l_mm=0.5n tb_cfar=0.1p
.param tb_len0=3
* DUT, far end shorted: at DC the caps are open, so v(txa) at 1 A is the series R
Xs txa rxa 0 chan_rlc len_mm={ch_len} kr={ch_kr} kc={ch_kc}
Vsh rxa 0 0
Iza 0 txa dc 1 ac 1
* DUT, far end open (Rleak only gives the DC operating point a path)
Xo txb rxb 0 chan_rlc len_mm={ch_len} kr={ch_kr} kc={ch_kc}
Rleak txb 0 1e12
Izb 0 txb dc 0 ac 1
* DUT with the subcircuit's own defaults (no len_mm/kr/kc): what consumers such as
* sim/channel-eye instantiate, so a changed default cannot hide behind the sweep
Xsd txc rxc 0 chan_rlc
Vshd rxc 0 0
Izc 0 txc dc 1 ac 1
Xod txd rxd 0 chan_rlc
Rleakd txd 0 1e12
Izd 0 txd dc 0 ac 1
* reference, far end shorted
Cya0 ya0 0 {ch_kc*tb_c_mm*ch_len/10/2}
Rya1 ya0 qya1 {ch_kr*tb_r_mm*ch_len/10}
Lya1 qya1 ya1 {tb_l_mm*ch_len/10}
Cya1 ya1 0 {ch_kc*tb_c_mm*ch_len/10}
Rya2 ya1 qya2 {ch_kr*tb_r_mm*ch_len/10}
Lya2 qya2 ya2 {tb_l_mm*ch_len/10}
Cya2 ya2 0 {ch_kc*tb_c_mm*ch_len/10}
Rya3 ya2 qya3 {ch_kr*tb_r_mm*ch_len/10}
Lya3 qya3 ya3 {tb_l_mm*ch_len/10}
Cya3 ya3 0 {ch_kc*tb_c_mm*ch_len/10}
Rya4 ya3 qya4 {ch_kr*tb_r_mm*ch_len/10}
Lya4 qya4 ya4 {tb_l_mm*ch_len/10}
Cya4 ya4 0 {ch_kc*tb_c_mm*ch_len/10}
Rya5 ya4 qya5 {ch_kr*tb_r_mm*ch_len/10}
Lya5 qya5 ya5 {tb_l_mm*ch_len/10}
Cya5 ya5 0 {ch_kc*tb_c_mm*ch_len/10}
Rya6 ya5 qya6 {ch_kr*tb_r_mm*ch_len/10}
Lya6 qya6 ya6 {tb_l_mm*ch_len/10}
Cya6 ya6 0 {ch_kc*tb_c_mm*ch_len/10}
Rya7 ya6 qya7 {ch_kr*tb_r_mm*ch_len/10}
Lya7 qya7 ya7 {tb_l_mm*ch_len/10}
Cya7 ya7 0 {ch_kc*tb_c_mm*ch_len/10}
Rya8 ya7 qya8 {ch_kr*tb_r_mm*ch_len/10}
Lya8 qya8 ya8 {tb_l_mm*ch_len/10}
Cya8 ya8 0 {ch_kc*tb_c_mm*ch_len/10}
Rya9 ya8 qya9 {ch_kr*tb_r_mm*ch_len/10}
Lya9 qya9 ya9 {tb_l_mm*ch_len/10}
Cya9 ya9 0 {ch_kc*tb_c_mm*ch_len/10}
Rya10 ya9 qya10 {ch_kr*tb_r_mm*ch_len/10}
Lya10 qya10 ya10 {tb_l_mm*ch_len/10}
Cya10 ya10 0 {ch_kc*tb_c_mm*ch_len/10/2}
Vyash ya10 0 0
Irya 0 ya0 dc 1 ac 1
* reference, far end open
Cyb0 yb0 0 {ch_kc*tb_c_mm*ch_len/10/2}
Ryb1 yb0 qyb1 {ch_kr*tb_r_mm*ch_len/10}
Lyb1 qyb1 yb1 {tb_l_mm*ch_len/10}
Cyb1 yb1 0 {ch_kc*tb_c_mm*ch_len/10}
Ryb2 yb1 qyb2 {ch_kr*tb_r_mm*ch_len/10}
Lyb2 qyb2 yb2 {tb_l_mm*ch_len/10}
Cyb2 yb2 0 {ch_kc*tb_c_mm*ch_len/10}
Ryb3 yb2 qyb3 {ch_kr*tb_r_mm*ch_len/10}
Lyb3 qyb3 yb3 {tb_l_mm*ch_len/10}
Cyb3 yb3 0 {ch_kc*tb_c_mm*ch_len/10}
Ryb4 yb3 qyb4 {ch_kr*tb_r_mm*ch_len/10}
Lyb4 qyb4 yb4 {tb_l_mm*ch_len/10}
Cyb4 yb4 0 {ch_kc*tb_c_mm*ch_len/10}
Ryb5 yb4 qyb5 {ch_kr*tb_r_mm*ch_len/10}
Lyb5 qyb5 yb5 {tb_l_mm*ch_len/10}
Cyb5 yb5 0 {ch_kc*tb_c_mm*ch_len/10}
Ryb6 yb5 qyb6 {ch_kr*tb_r_mm*ch_len/10}
Lyb6 qyb6 yb6 {tb_l_mm*ch_len/10}
Cyb6 yb6 0 {ch_kc*tb_c_mm*ch_len/10}
Ryb7 yb6 qyb7 {ch_kr*tb_r_mm*ch_len/10}
Lyb7 qyb7 yb7 {tb_l_mm*ch_len/10}
Cyb7 yb7 0 {ch_kc*tb_c_mm*ch_len/10}
Ryb8 yb7 qyb8 {ch_kr*tb_r_mm*ch_len/10}
Lyb8 qyb8 yb8 {tb_l_mm*ch_len/10}
Cyb8 yb8 0 {ch_kc*tb_c_mm*ch_len/10}
Ryb9 yb8 qyb9 {ch_kr*tb_r_mm*ch_len/10}
Lyb9 qyb9 yb9 {tb_l_mm*ch_len/10}
Cyb9 yb9 0 {ch_kc*tb_c_mm*ch_len/10}
Ryb10 yb9 qyb10 {ch_kr*tb_r_mm*ch_len/10}
Lyb10 qyb10 yb10 {tb_l_mm*ch_len/10}
Cyb10 yb10 0 {ch_kc*tb_c_mm*ch_len/10/2}
Cybfar yb10 0 {tb_cfar}
Rybleak yb0 0 1e12
Iryb 0 yb0 dc 0 ac 1
* fixed nominal references (declared length 3 mm, kr = kc = 1) for the default instances
Cyc0 yc0 0 {tb_c_mm*tb_len0/10/2}
Ryc1 yc0 qyc1 {tb_r_mm*tb_len0/10}
Lyc1 qyc1 yc1 {tb_l_mm*tb_len0/10}
Cyc1 yc1 0 {tb_c_mm*tb_len0/10}
Ryc2 yc1 qyc2 {tb_r_mm*tb_len0/10}
Lyc2 qyc2 yc2 {tb_l_mm*tb_len0/10}
Cyc2 yc2 0 {tb_c_mm*tb_len0/10}
Ryc3 yc2 qyc3 {tb_r_mm*tb_len0/10}
Lyc3 qyc3 yc3 {tb_l_mm*tb_len0/10}
Cyc3 yc3 0 {tb_c_mm*tb_len0/10}
Ryc4 yc3 qyc4 {tb_r_mm*tb_len0/10}
Lyc4 qyc4 yc4 {tb_l_mm*tb_len0/10}
Cyc4 yc4 0 {tb_c_mm*tb_len0/10}
Ryc5 yc4 qyc5 {tb_r_mm*tb_len0/10}
Lyc5 qyc5 yc5 {tb_l_mm*tb_len0/10}
Cyc5 yc5 0 {tb_c_mm*tb_len0/10}
Ryc6 yc5 qyc6 {tb_r_mm*tb_len0/10}
Lyc6 qyc6 yc6 {tb_l_mm*tb_len0/10}
Cyc6 yc6 0 {tb_c_mm*tb_len0/10}
Ryc7 yc6 qyc7 {tb_r_mm*tb_len0/10}
Lyc7 qyc7 yc7 {tb_l_mm*tb_len0/10}
Cyc7 yc7 0 {tb_c_mm*tb_len0/10}
Ryc8 yc7 qyc8 {tb_r_mm*tb_len0/10}
Lyc8 qyc8 yc8 {tb_l_mm*tb_len0/10}
Cyc8 yc8 0 {tb_c_mm*tb_len0/10}
Ryc9 yc8 qyc9 {tb_r_mm*tb_len0/10}
Lyc9 qyc9 yc9 {tb_l_mm*tb_len0/10}
Cyc9 yc9 0 {tb_c_mm*tb_len0/10}
Ryc10 yc9 qyc10 {tb_r_mm*tb_len0/10}
Lyc10 qyc10 yc10 {tb_l_mm*tb_len0/10}
Cyc10 yc10 0 {tb_c_mm*tb_len0/10/2}
Vycsh yc10 0 0
Iryc 0 yc0 dc 1 ac 1
Cyd0 yd0 0 {tb_c_mm*tb_len0/10/2}
Ryd1 yd0 qyd1 {tb_r_mm*tb_len0/10}
Lyd1 qyd1 yd1 {tb_l_mm*tb_len0/10}
Cyd1 yd1 0 {tb_c_mm*tb_len0/10}
Ryd2 yd1 qyd2 {tb_r_mm*tb_len0/10}
Lyd2 qyd2 yd2 {tb_l_mm*tb_len0/10}
Cyd2 yd2 0 {tb_c_mm*tb_len0/10}
Ryd3 yd2 qyd3 {tb_r_mm*tb_len0/10}
Lyd3 qyd3 yd3 {tb_l_mm*tb_len0/10}
Cyd3 yd3 0 {tb_c_mm*tb_len0/10}
Ryd4 yd3 qyd4 {tb_r_mm*tb_len0/10}
Lyd4 qyd4 yd4 {tb_l_mm*tb_len0/10}
Cyd4 yd4 0 {tb_c_mm*tb_len0/10}
Ryd5 yd4 qyd5 {tb_r_mm*tb_len0/10}
Lyd5 qyd5 yd5 {tb_l_mm*tb_len0/10}
Cyd5 yd5 0 {tb_c_mm*tb_len0/10}
Ryd6 yd5 qyd6 {tb_r_mm*tb_len0/10}
Lyd6 qyd6 yd6 {tb_l_mm*tb_len0/10}
Cyd6 yd6 0 {tb_c_mm*tb_len0/10}
Ryd7 yd6 qyd7 {tb_r_mm*tb_len0/10}
Lyd7 qyd7 yd7 {tb_l_mm*tb_len0/10}
Cyd7 yd7 0 {tb_c_mm*tb_len0/10}
Ryd8 yd7 qyd8 {tb_r_mm*tb_len0/10}
Lyd8 qyd8 yd8 {tb_l_mm*tb_len0/10}
Cyd8 yd8 0 {tb_c_mm*tb_len0/10}
Ryd9 yd8 qyd9 {tb_r_mm*tb_len0/10}
Lyd9 qyd9 yd9 {tb_l_mm*tb_len0/10}
Cyd9 yd9 0 {tb_c_mm*tb_len0/10}
Ryd10 yd9 qyd10 {tb_r_mm*tb_len0/10}
Lyd10 qyd10 yd10 {tb_l_mm*tb_len0/10}
Cyd10 yd10 0 {tb_c_mm*tb_len0/10/2}
Cydfar yd10 0 {tb_cfar}
Rydleak yd0 0 1e12
Iryd 0 yd0 dc 0 ac 1
* bare inductors of the declared total L, driven like the ladders: Im Z at the L probe
* is omega * L_declared, the quantity the ladder's bias is measured against
Lyl yl0 0 {tb_l_mm*ch_len}
Iryl 0 yl0 dc 0 ac 1
Lyn yn0 0 {tb_l_mm*tb_len0}
Iryn 0 yn0 dc 0 ac 1
* the PVT-FULL supply axis rides this dummy rail: the ladder is linear and
* supply-free, so the source exists only that corners.supply_v has a name to alter
Vpvt vpvt 0 dc 1.2
