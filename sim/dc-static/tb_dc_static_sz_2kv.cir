* tb_dc_static_sz_2kv.cir -- tb_dc_static.cir with the parametric pad cell (issue #251 T-16 sizing study): T-08 and T-24 per candidate.
* Spec rows: T-06, T-07, T-08, T-11, T-24, T-28 (spec/target-spec.md).
* Circuit body only (klt sim owns the .control block). The cells under test are
* included from design/, never copied. The sub-benches share the VDDIO supply
* source Vddio, which the request's corners.supply_v alters per corner.
*
* Pin assembly used here (the I/O-cell assembly itself is a separate issue):
* the driver and the primary ESD stage sit on the external pad node PAD, the
* receiver sits behind the ESD series resistor on PADI.
Vddio vddio 0 dc 1.2
.include ../../design/aib_tx_data.spice
.include ../../design/aib_rx_data.spice
.include ../channel-eye/esd_sz_2kv.inc
.include tb_drive.cir
.include tb_pin.cir
.include tb_rx_hyst.cir
