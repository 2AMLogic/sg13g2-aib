** klt-netlist-inputs: {"pdk_variant": "ihp-sg13g2", "rcfile": "xschemrc", "xschem_version": "3.4.7"}
** sch_path: design/aib_rx_inv.sch
.subckt aib_rx_inv PAD DOUT VDDIO VSS
*.PININFO PAD:I DOUT:O VDDIO:B VSS:B
XMi1p M1 PAD VDDIO VDDIO sg13_lv_pmos w=2.5u l=0.13u ng=2 m=1
XMi1n M1 PAD VSS VSS sg13_lv_nmos w=1u l=0.13u ng=2 m=1
XMi2p DOUT M1 VDDIO VDDIO sg13_lv_pmos w=4u l=0.13u ng=2 m=1
XMi2n DOUT M1 VSS VSS sg13_lv_nmos w=2u l=0.13u ng=2 m=1
.ends
