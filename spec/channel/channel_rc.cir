* channel_rc.cir -- declared die-to-die channel model, CH-3MM-RC (spec/channel-model.md)
*
* A declared model, not a measured one. Per-mm values and their provenance are in
* spec/channel-model.md. This file is the form the simulations include.
*
*   .include channel_rc.cir
*   Xch tx_pin rx_pin gnd chan_rlc
*
* Parameters (override with .param before the .include, or per instance):
*   len_mm  channel length in mm                       3 (CH-3MM-RC); 1 (CH-1MM); 5 (CH-5MM)
*   r_mm    series resistance per mm, ohm/mm           5.5
*   c_mm    shunt capacitance per mm, F/mm             0.20p
*   l_mm    series inductance per mm, H/mm             0.5n
*   kr kc   process spread multipliers on R and C      1 (use 0.8 and 1.2 for the +-20 % corners)
*   cfar    far-end load at the rx pin, F              0.1p
*
* Ten uniform RLC pi-sections. Each section is len_mm/10 long (0.3 mm at 3 mm,
* about 3 ps of delay), so the ladder is valid far above the signal bandwidth.
* The far-end load cfar is part of the model so that every simulation sees the
* same receiver-side loading; do not add it again in the testbench.

.subckt chan_rlc tx rx gnd params: len_mm=3 r_mm=5.5 c_mm=0.20p l_mm=0.5n kr=1 kc=1 cfar=0.1p
.param seg_r={kr*r_mm*len_mm/10} seg_l={l_mm*len_mm/10} seg_c={kc*c_mm*len_mm/10}
C0  n0  gnd {seg_c/2}
R1  n0  m1  {seg_r}
L1  m1  n1  {seg_l}
C1  n1  gnd {seg_c}
R2  n1  m2  {seg_r}
L2  m2  n2  {seg_l}
C2  n2  gnd {seg_c}
R3  n2  m3  {seg_r}
L3  m3  n3  {seg_l}
C3  n3  gnd {seg_c}
R4  n3  m4  {seg_r}
L4  m4  n4  {seg_l}
C4  n4  gnd {seg_c}
R5  n4  m5  {seg_r}
L5  m5  n5  {seg_l}
C5  n5  gnd {seg_c}
R6  n5  m6  {seg_r}
L6  m6  n6  {seg_l}
C6  n6  gnd {seg_c}
R7  n6  m7  {seg_r}
L7  m7  n7  {seg_l}
C7  n7  gnd {seg_c}
R8  n7  m8  {seg_r}
L8  m8  n8  {seg_l}
C8  n8  gnd {seg_c}
R9  n8  m9  {seg_r}
L9  m9  n9  {seg_l}
C9  n9  gnd {seg_c}
R10 n9  m10 {seg_r}
L10 m10 n10 {seg_l}
C10 n10 gnd {seg_c/2}
Cfar n10 gnd {cfar}
* zero-volt sources: current probes, i(Xch.vtx0) is the TX-pin current
Vtx0 tx n0 0
Vrx0 n10 rx 0
.ends chan_rlc
